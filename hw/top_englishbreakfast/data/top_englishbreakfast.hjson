// Copyright lowRISC contributors (OpenTitan project).
// Licensed under the Apache License, Version 2.0, see LICENSE for details.
// SPDX-License-Identifier: Apache-2.0
//
// TOP English Breakfast configuration
{ name: "englishbreakfast",
  type: "top",

  // 32-bit datawidth
  datawidth: "32",

  // Power information for the design
  power: {
    // Power domains supported by the design
    domains: ["Aon", "Main"],

    // Default power domain used for the design
    default: "Main"

    // Discrete OpenTitan does not need to wait for external resets
    wait_for_external_reset: false
  },

  // List of unmanaged external clocks
  unmanaged_clocks: [
    // { name: "my_ext" }
  ]

  // This is the clock data structure of the design.
  // The src key indicates the raw clock sources in the design
  // The groups key indicates the various clock groupings in the design
  clocks: {

    // Clock Source attributes
    // name: Name of group.
    // aon:  Whether the clock is free running all the time.
    //       If it is, the clock is not handled by clkmgr.
    // freq: Absolute frequency of clk in Hz
    srcs: [
      { name: "main", aon: "no",  freq: "100000000" }
      { name: "io",   aon: "no",  freq: "96000000" }
      { name: "usb",  aon: "no",  freq: "48000000" }
      { name: "aon",  aon: "yes", freq: "200000" }
    ],

    // Derived clock source attributes
    // name: Name of group.
    // aon:  Whether the clock is free running all the time.
    //       If it is, the clock is not handled by clkmgr.
    // freq: Absolute frequency of clk in Hz
    // src:  From which clock source is the clock derived
    // div:  Ratio between derived clock and source clock
    derived_srcs: [
      { name: "io_div4", aon: "no", div: 4, src: "io", freq: "24000000" }
    ],

    // Clock Group attributes
    // name: name of group.
    //
    // src: The hierarchical source of the clock
    // "ext"  - clock is supplied from a port of the top module
    // "top"  - clock is supplied from a net inside the top module
    //
    // sw_cg: whether software is allowed to gate the clock
    // "no"   - software is not allowed to gate clocks
    // "yes"  - software is allowed to gate clocks
    // "hint" - software can provide a hint, and hw controls the rest
    //
    // unique: whether each module in the group can be separately gated
    //         if sw_cg is "no", this field has no meaning
    // "yes"  - each clock is individually controlled
    // "no"   - the group is controlled as one single unit
    //
    // The powerup and proc groups are unique.
    // The powerup group of clocks do not feed through the clock
    // controller as they manage clock controller behavior
    // The proc group is not peripheral, and directly hardwired

    groups: [
      // the ast group is used to represent input clocks to the top
      { name: "ast",     src:"ext", sw_cg: "no"                   }
      // the powerup group is used exclusively by clk/pwr/rstmgr/pinmux
      { name: "ast",     src:"ext", sw_cg: "no"                   }
      { name: "powerup", src:"top", sw_cg: "no"                   }
      { name: "trans",   src:"top", sw_cg: "hint", unique: "yes", }
      { name: "infra",   src:"top", sw_cg: "no",                  }
      { name: "secure",  src:"top", sw_cg: "no"                   }
      { name: "peri",    src:"top", sw_cg: "yes",  unique: "no"   }
      { name: "timers",  src:"top", sw_cg: "no"                   }
      { name: "proc",
        src: "no",
        sw_cg: "no",
        unique: "no",
        clocks: {
          clk_proc_main: main
        }
      }
    ],
  },

  // List of unmanaged external resets
  unmanaged_resets: [
    // { name: "my_ext" }
  ]

  // This is the reset data structure of the design.
  // The node key represents all the known resets in the design
  resets: {

    // Reset node attributes
    // name: name of reset.
    //
    // gen: whether the reset is generated
    // true: it is a generated reset inside rstmgr
    // false: it is a hardwired design reset inside rstmgr (roots and por)
    // For non-generated resets, the parent / domain definitions have no meaning.
    //
    // type: the reset type [ext, top]
    // ext: the reset is coming in from the ports, external to englishbreakfast
    // int: the reset is only used inside rstmgr
    // top: the reset is output from rstmgr to top level struct
    //
    // parent: The parent reset
    // If type is "ext", there is no root, since it is external
    //
    // domains: The power domains of a particular reset
    // This is a list of the supported power domains.
    // Valid values are Aon and (power domain)0 ~ (power domain)1.
    // If no value is supplied, the default is only the Aon version.
    //
    // clk:  related clock domain for synchronous release
    // If type is "por", there is not related clock, since it is
    // likely external or generated from a voltage comparator
    //
    nodes: [
      { name: "por_aon",     gen: false, type: "top",                    clock: "aon"     }
      { name: "lc_src",      gen: false, type: "int",                    clock: "io_div4" }
      { name: "sys_src",     gen: false, type: "int",                    clock: "io_div4" }
      { name: "por",         gen: true,  type: "top", parent: "por_aon", clock: "main"    }
      { name: "por_io",      gen: true,  type: "top", parent: "por_aon", clock: "io"      }
      { name: "por_io_div4", gen: true , type: "top", parent: "por_aon", clock: "io_div4" }
      { name: "por_usb",     gen: true,  type: "top", parent: "por_aon", clock: "usb"     }
      { name: "lc",          gen: true,  type: "top", parent: "lc_src",  clock: "main"    }
      { name: "lc_io_div4",  gen: true,  type: "top", parent: "lc_src",  clock: "io_div4" }
      { name: "sys",         gen: true,  type: "top", parent: "sys_src", clock: "main"    }
      { name: "sys_io_div4", gen: true,  type: "top", parent: "sys_src", clock: "io_div4" }
      { name: "sys_aon",     gen: true,  type: "top", parent: "sys_src", clock: "aon"     }
      { name: "spi_device",  gen: true,  type: "top", parent: "sys_src", clock: "io_div4", sw: true }
      { name: "spi_host0",   gen: true,  type: "top", parent: "sys_src", clock: "io",      sw: true }
      { name: "usb",         gen: true,  type: "top", parent: "sys_src", clock: "usb",     sw: true }
    ]
  }
  // The reset requests: peripherals are deduced, but internal and debug need
  // to be configure in hjson file.
  reset_requests: {
    int: [
      {
        "name": "MainPwr",
        "desc": "main power glitch reset request",
        "module": "pwrmgr"
      },
      {
        "name": "Esc",
        "desc": "escalation reset request",
        "module": "alert_handler"
      }
    ],
    debug: [
      {
        "name": "Ndm",
        "desc": "non-debug-module reset request",
        "module": "rv_dm"
      }
    ],
  },

  // Number of cores: used in rv_plic and timer
  num_cores: "1",

  // Any module with interrupts that doesn't specify plic
  // will have its interrupts sent here
  default_plic: "rv_plic"

  // Any module with alerts that doesn't specify alert_handler
  // will have its alerts sent here
  default_alert_handler: null


  // `addr_spaces` names the distinct address spaces present in the device.
  // All hosts in the same address space share the same base addresses for
  // all peripherals, though not every peripheral will be accessible to every
  // host in that address space--Access privileges are separate from addresses.
  addr_spaces: [
    { name: "hart",
      desc: "The main address space, shared between the CPU and DM"
      subspaces: [
        { name: "mmio",
          desc: '''
                MMIO region excludes any memory that is separate from the module configuration
                space, i.e. ROM, main SRAM, and flash are excluded but retention SRAM, spi_device
                memory, or usbdev memory are included.
                '''
          nodes: [
            "uart0",
            "uart1",
            "gpio0",
            "spi_device",
            "rv_timer"
            "spi_host0",
            "usbdev",
            "pwrmgr",
            "rstmgr",
            "clkmgr",
            "pinmux",
            "aon_timer",
            "ast",
            "flash_ctrl.core",
            "flash_ctrl.prim",
            "rv_plic",
            "aes",
            "sram_ctrl_main.regs"
            "rom_ctrl.regs",
            "rv_core_ibex"
          ]
        }
      ]
    },
  ]

  // `module` defines the peripherals.
  // Details are coming from each modules' config file `ip.hjson`
  // TODO: Define parameter here
  // attr: There are a few types of modules supported
     //   normal(default): Normal, non-templated modules that will be instantiated
     //   templated:   These modules are templated and must be run through topgen
     //   reggen_top:  These modules are not templated, but need to have reggen run
     //                because they live exclusively in hw/top_* instead of hw/ip_*.
     //                These modules are also instantiated in the top level.
     //   reggen_only: Similar to reggen_top, but are not instantiated in the top level.
  module: [
    { name: "uart0",    // instance name
      type: "uart",     // Must be matched to the ip name in `ip.hjson` (_reg, _cfg permitted)
                        // and `hw/ip/{type}`

      // clock connections defines the port to top level clock connection
      // the ip.hjson will declare the clock port names
      // If none are defined at ip.hjson, clk_i is used by default
      clock_srcs: {clk_i: "io_div4"},
      clock_group: "peri",
      // reset connections defines the port to top level reset connection
      // the ip.hjson will declare the reset port names
      // If none are defined at ip.hjson, rst_ni is used by default
      reset_connections: {rst_ni: "lc_io_div4"},
      base_addr: {
        hart: "0x40000000",
      },
      outgoing_alert: "englishbreakfast",
    },
    { name: "uart1",    // instance name
      type: "uart",     // Must be matched to the ip name in `ip.hjson` (_reg, _cfg permitted)
                        // and `hw/ip/{type}`

      // clock connections defines the port to top level clock connection
      // the ip.hjson will declare the clock port names
      // If none are defined at ip.hjson, clk_i is used by default
      clock_srcs: {clk_i: "io_div4"},
      clock_group: "peri",
      // reset connections defines the port to top level reset connection
      // the ip.hjson will declare the reset port names
      // If none are defined at ip.hjson, rst_ni is used by default
      reset_connections: {rst_ni: "lc_io_div4"},
      base_addr: {
        hart: "0x40010000",
      },
      outgoing_alert: "englishbreakfast",
    },
    { name: "gpio0",
      type: "gpio",
      template_type: "gpio",
      clock_srcs: {clk_i: "io_div4"},
      clock_group: "peri",
      reset_connections: {rst_ni: "sys_io_div4"},
      base_addr: {
        hart: "0x40040000",
      },
      param_decl: {
        GpioAsyncOn: "1"
      },
      attr: "ipgen"
      outgoing_alert: "englishbreakfast",
    }
    { name: "spi_device",
      type: "spi_device",
      clock_srcs: {clk_i: "io_div4", scan_clk_i: "io_div4"},
      clock_group: "peri",
      reset_connections: {rst_ni: "spi_device"},
      base_addr: {
        hart: "0x40050000",
      },
      outgoing_alert: "englishbreakfast",
    },
    { name: "spi_host0",
      type: "spi_host",
      clock_srcs: {clk_i: "io"},
      clock_group: "peri",
      reset_connections: {rst_ni: "spi_host0"},
      base_addr: {
        hart: "0x40060000",
      },
      outgoing_alert: "englishbreakfast",
    },
    { name: "rv_timer",
      type: "rv_timer",
      clock_srcs: {clk_i: "io_div4"},
      clock_group: "timers",
      reset_connections: {rst_ni: "sys_io_div4"},
      base_addr: {
        hart: "0x40100000",
      },
      outgoing_alert: "englishbreakfast",
    },
    { name: "usbdev",
      type: "usbdev",
      clock_srcs: {clk_i: "usb", clk_aon_i: "aon"},
      clock_group: "peri",
      reset_connections: {rst_ni: "usb", rst_aon_ni: "sys_aon"},
      base_addr: {
        hart: "0x40320000",
      },
      outgoing_alert: "englishbreakfast",
    },
    { name: "pwrmgr",
      type: "pwrmgr",
      template_type: "pwrmgr",
      clock_srcs: {clk_i: "io_div4", clk_slow_i: "aon", clk_lc_i: "io_div4", clk_esc_i: "io_div4"},
      clock_group: "powerup",
      reset_connections: {
        rst_ni: "por_io_div4",
        rst_lc_ni: "lc_io_div4",
        rst_esc_ni: "lc_io_div4",
        rst_main_ni: "por_aon",
        rst_slow_ni: "por_aon"
      },
      domain: "Aon",
      base_addr: {
        hart: "0x40400000",
      },
      attr: "ipgen",
      outgoing_alert: "englishbreakfast",
    },
    { name: "rstmgr",
      type: "rstmgr",
      template_type: "rstmgr",
      clock_srcs: {clk_i: "io_div4", clk_por_i: "io_div4", clk_aon_i: "aon", clk_main_i: "main", clk_io_i: "io", clk_usb_i: "usb",
                   clk_io_div4_i: "io_div4"},
      clock_group: "powerup",
      reset_connections: {rst_ni: "lc_io_div4", rst_por_ni: "por_io_div4"},
      domain: "Aon",
      base_addr: {
        hart: "0x40410000",
      },
      param_decl: {
        SecCheck: "0",
      }
      attr: "ipgen",
      outgoing_alert: "englishbreakfast",
    },
    { name: "clkmgr",
      type: "clkmgr",
      template_type: "clkmgr",
      clock_srcs: {
        clk_i: "io_div4",
        clk_main_i: {
          group: "ast",
          clock: "main"
        },
        clk_io_i: {
          group: "ast",
          clock: "io"
        },
        clk_usb_i: {
          group: "ast",
          clock: "usb"
        },
        clk_aon_i: {
          group: "ast",
          clock: "aon"
        }
      },
      clock_group: "powerup",
      reset_connections: {rst_ni: "por_io_div4",
                          rst_aon_ni: "por_aon",
                          rst_io_ni: "por_io",
                          rst_io_div4_ni: "por_io_div4",
                          rst_main_ni: "por",
                          rst_usb_ni: "por_usb",
                          rst_root_ni: "por_io_div4",
                          rst_root_io_ni: "por_io",
                          rst_root_io_div4_ni: "por_io_div4",
                          rst_root_main_ni: "por",
                          rst_root_usb_ni: "por_usb",
                         },
      domain: "Aon",
      base_addr: {
        hart: "0x40420000",
      },
      attr: "ipgen",
      outgoing_alert: "englishbreakfast",
    },
    { name: "pinmux",
      type: "pinmux",
      template_type: "pinmux",
      clock_srcs: {
        primary: {clk_i: "io_div4", clk_aon_i: "aon"},
        secondary: {clk_i: "io_div4"},
      },
      clock_group: {primary: "powerup", secondary: "powerup"},
      reset_connections: {
        primary: {
          rst_ni: {
            name: "lc_io_div4",
            domain: "Aon",
          },
          rst_aon_ni: {
            name: "sys_aon",
            domain: "Aon"
          },
          rst_sys_ni: {
            name: "sys_io_div4",
            domain: "Aon",
          },
        },
        secondary: {
          rst_ni: {
            name: "lc_io_div4",
            domain: "Aon",
          },
        },
      }
      domain: "Main",
      domain_secondary: "Aon",
      base_addr: {
        hart: "0x40460000",
      },
      attr: "ipgen",
      outgoing_alert: "englishbreakfast",
    },
    { name: "aon_timer",
      type: "aon_timer",
      clock_srcs: {clk_i: "io_div4", clk_aon_i: "aon"},
      clock_group: "timers",
      reset_connections: {rst_ni: "sys_io_div4", rst_aon_ni: "sys_aon"},
      domain: "Aon",
      base_addr: {
        hart: "0x40470000",
      },
      outgoing_alert: "englishbreakfast",
    },
    { name: "ast",
      type: "ast",
      clock_srcs: {
        clk_ast_tlul_i: {
          clock: "io_div4",
          group: "secure"
        },
        clk_ast_adc_i: {
          clock: "aon",
          group: "secure"
        },
        clk_ast_alert_i: {
          clock: "io_div4",
          group: "secure"
        },
        clk_ast_es_i: {
          clock: "main",
          group: "secure"
        },
        clk_ast_rng_i: {
          clock: "main",
          group: "secure"
        },
        clk_ast_usb_i: {
          clock: "usb",
          group: "peri"
        }
      },
      clock_group: "secure",
      reset_connections: {
        rst_ast_tlul_ni: "lc_io_div4",
        rst_ast_adc_ni: "sys_aon",
        rst_ast_alert_ni: "lc_io_div4",
        rst_ast_es_ni: "sys",
        rst_ast_rng_ni: "sys",
        rst_ast_usb_ni: "usb"
      },
      base_addr: {
        hart: "0x40480000",
      },
      attr: "reggen_only",
    },
    { name: "flash_ctrl",
      type: "flash_ctrl",
      template_type: "flash_ctrl",
      clock_srcs: {clk_i: "main", clk_otp_i: "io_div4"},
      clock_group: "infra",
      reset_connections: {rst_ni: "lc", rst_otp_ni: "lc_io_div4"},
      base_addrs: {
        core: {hart: "0x41000000"},
        prim: {hart: "0x41008000"},
        mem:  {hart: "0x20000000"}
      }
      param_decl: {
        SecScrambleEn: "0"
      }
      memory: {
        mem: {
          label:      "eflash",
          swaccess:   "ro",
          exec:       "True",
          byte_write: "False",
          config: {
            type: "flash",
            banks: 2,
            pages_per_bank: 16,
            program_resolution: 8, // maximum number of flash words allowed to program at one time
          }
        }
      }
      attr: "ipgen",
      outgoing_alert: "englishbreakfast",
    },
    { name: "rv_plic",
      type: "rv_plic",
      template_type: "rv_plic",
      clock_srcs: {clk_i: "main"},
      clock_group: "secure",
      reset_connections: {rst_ni: "sys"},
      base_addr: {
        hart: "0x48000000",
      },
      attr: "ipgen",
      targets: ["rv_core_ibex"]
      outgoing_alert: "englishbreakfast",
    },
    { name: "aes",
      type: "aes",
      clock_srcs: {clk_i: "main", clk_edn_i: "main"},
      clock_group: "trans",
      reset_connections: {rst_ni: "sys", rst_edn_ni: "sys"},
      param_decl: {
        AESGCMEnable: "1",
        SecMasking: "1",
        SecSBoxImpl: "aes_pkg::SBoxImplDom"
      }
      base_addr: {
        hart: "0x41100000",
      },
      outgoing_alert: "englishbreakfast",
    },
    { name: "sram_ctrl_main",
      type: "sram_ctrl",
      clock_srcs: {clk_i: "main", clk_otp_i: "io_div4"},
      clock_group: "secure",
      reset_connections: {rst_ni: "sys", rst_otp_ni: "lc_io_div4"},
      param_decl: {
        InstrExec: "1",
      }
      base_addrs: {
        regs: {hart: "0x411C0000"},
        ram:  {hart: "0x10000000"},
      },
      // Memory regions must be associated with a dedicated
      // TL-UL device interface.
      memory: {
        ram: {
          label:      "ram_main",
          swaccess:   "rw",
          exec:       "True",
          byte_write: "True",
          size:       "0x20000"
        }
      }
      outgoing_alert: "englishbreakfast",
    },
    { name: "rom_ctrl",
      type: "rom_ctrl",
      clock_srcs: {clk_i: "main"},
      clock_group: "infra",
      reset_connections: {rst_ni: "sys"},
      base_addrs: {
        rom:  {hart: "0x00008000"},
        regs: {hart: "0x411e0000"},
      }
      memory: {
        rom: {
          label:      "rom",
          swaccess:   "ro",
          exec:       "True",
          byte_write: "False",
          size:       "0x8000"
        }
      },
      param_decl: {
        SecDisableScrambling: "1'b1"
      }
      outgoing_alert: "englishbreakfast",
    },
    { name: "rv_core_ibex",
      type: "rv_core_ibex",
      template_type: "rv_core_ibex",
      attr: "ipgen",
      ipgen_params: {
        num_regions: 2
      }
      param_decl: {PMPEnable: "0",
                   PMPGranularity: "0",
                   PMPNumRegions: "16",
                   MHPMCounterNum: "0",
                   MHPMCounterWidth: "32",
                   RV32E: "0",
                   RV32M: "ibex_pkg::RV32MSingleCycle",
                   RV32B: "ibex_pkg::RV32BNone",
                   RV32ZC: "ibex_pkg::RV32ZcaZcbZcmp",
                   RegFile: "ibex_pkg::RegFileFF",
                   BranchTargetALU: "1",
                   WritebackStage: "1",
                   ICache: "0",
                   ICacheECC: "0",
                   BranchPredictor: "0",
                   DbgTriggerEn: "1",
                   SecureIbex: "0",
                   DmHaltAddr: "0",
                   DmExceptionAddr: "0",
                   PipeLine: "0"
                  }
      clock_srcs: {clk_i: "main",
                   clk_edn_i: "main",
                   clk_esc_i: "io_div4",
                   clk_otp_i: "io_div4"},
      clock_group: "infra",
      reset_connections: {rst_ni: "sys",
                          rst_edn_ni: "sys",
                          rst_esc_ni: "lc_io_div4",
                          rst_otp_ni: "lc_io_div4"},
      base_addr: {
        hart: "0x411F0000",
      },
      outgoing_alert: "englishbreakfast",
    },
  ]

  // The port data structure is not something that should be used liberally.
  // It is used specifically to assign special attributes to specific ports.
  // For example, this allows us to designate a port as part of inter-module
  // connections.
  port: [
    { name: "ast",
      inter_signal_list: [
        { struct: "edn",
          type: "req_rsp",
          name: "edn",
          // The activity direction for a port inter-signal is "opposite" of
          // what the external module actually needs.
          act:  "rsp",
          package: "edn_pkg",
        },

        { struct: "lc_tx",
          type: "uni",
          name: "lc_dft_en",
          // The activity direction for a port inter-signal is "opposite" of
          // what the external module actually needs.
          act:  "req",
          package: "lc_ctrl_pkg",
        },

        { struct:  "ram_1p_cfg_req",
          package: "prim_ram_1p_pkg",
          type:    "uni",
          name:    "ram_1p_cfg",
          // The activity direction for a port inter-signal is "opposite" of
          // what the external module actually needs.
          act:     "rcv"
        },

        { struct:  "ram_1r1w_cfg_req",
          package: "prim_ram_1r1w_pkg",
          type:    "uni",
          name:    "ram_1r1w_cfg",
          // The activity direction for a port inter-signal is "opposite" of
          // what the external module actually needs.
          act:     "rcv"
        },


        { struct:  "rom_cfg_req",
          package: "prim_rom_pkg",
          type:    "uni",
          name:    "rom_cfg",
          // The activity direction for a port inter-signal is "opposite" of
          // what the external module actually needs.
          act:     "rcv"
        },
      ]
    },
  ]

  // Inter-module Connection.
  // format:
  //    requester: [ resp1, resp2, ... ],
  //
  //  the field and value should be module_inst.port_name
  //  e.g flash_ctrl0.flash: [flash_phy0.flash_ctrl]
  inter_module: {
    'connect': {
      'pwrmgr.pwr_nvm'          : ['flash_ctrl.pwrmgr'],
      'pwrmgr.pwr_rst'          : ['rstmgr.pwr'],
      'pwrmgr.pwr_clk'          : ['clkmgr.pwr'],
      'pwrmgr.strap'            : ['pinmux.strap_en'],
      'pwrmgr.low_power'        : ['pinmux.sleep_en',
                                   'aon_timer.sleep_mode'],
      'pwrmgr.fetch_en'         : ['rv_core_ibex.pwrmgr_cpu_en'],

      // usbdev connection to pinmux
      'usbdev.usb_dp_pullup'      : ['pinmux.usbdev_dppullup_en'],
      'usbdev.usb_dn_pullup'      : ['pinmux.usbdev_dnpullup_en'],
      'usbdev.usb_aon_suspend_req': ['pinmux.usbdev_suspend_req'],
      'usbdev.usb_aon_wake_ack'   : ['pinmux.usbdev_wake_ack'],
      'usbdev.usb_aon_bus_reset'  : ['pinmux.usbdev_bus_reset'],
      'usbdev.usb_aon_sense_lost' : ['pinmux.usbdev_sense_lost'],
      'pinmux.usbdev_wake_detect_active' : ['usbdev.usb_aon_wake_detect_active'],

      // The idle connection is automatically connected through topgen.
      // The user does not need to explicitly declare anything other than
      // an empty list.
      'clkmgr.idle'             : [],

      // rv_plic connections
      'rv_plic.msip' : ['rv_core_ibex.irq_software'],
      'rv_plic.irq'  : ['rv_core_ibex.irq_external'],

      // rv_timer connections


      // rv core ibex connections
      'rv_core_ibex.crash_dump' : ['rstmgr.cpu_dump'],
      'rv_core_ibex.pwrmgr'     : ['pwrmgr.pwr_cpu'],

      // spi passthrough connection
      'spi_device.passthrough'     : ['spi_host0.passthrough']

      // Reset manager software reset request to pwrmgr
      'rstmgr.sw_rst_req' : ['pwrmgr.sw_rst_req'],
    }

    // top is to connect to top net/struct.
    // It defines the signal in the top and connect from the module,
    // use of the signal is up to top template
    'top': [
        // top level net for clocks
        'clkmgr.clocks',

        // top level clock gating indications for alert subsystem
        'clkmgr.cg_en',

        // top level net for reset
        'rstmgr.resets',

        // top level reset asserted indications for alert subsystem
        'rstmgr.rst_en',

        // dedicated timer interrupt
        'rv_core_ibex.irq_timer',

        // hardwired connections
        'rv_core_ibex.hart_id', 'rv_core_ibex.boot_addr',

        // Xbars

        // Pinmux JTAG signals for the tool-inserted DFT TAP
        'pinmux.dft_jtag'
    ],

    // ext is to create port in the top.
    'external': {
        'clkmgr.clocks'                  : '',
        'clkmgr.cg_en'                   : '',
        'clkmgr.jitter_en'               : 'clk_main_jitter_en',
        'clkmgr.hi_speed_sel'            : 'hi_speed_sel',
        'clkmgr.div_step_down_req'       : 'div_step_down_req',
        'clkmgr.all_clk_byp_req'         : 'all_clk_byp_req',
        'clkmgr.all_clk_byp_ack'         : 'all_clk_byp_ack',
        'clkmgr.io_clk_byp_req'          : 'io_clk_byp_req',
        'clkmgr.io_clk_byp_ack'          : 'io_clk_byp_ack',
        'flash_ctrl.flash_bist_enable'   : 'flash_bist_enable',
        'flash_ctrl.flash_power_down_h'  : 'flash_power_down_h',
        'flash_ctrl.flash_power_ready_h' : 'flash_power_ready_h',
        'flash_ctrl.obs_ctrl'            : 'obs_ctrl',
        'flash_ctrl.fla_obs'             : 'flash_obs',
        'peri.tl_ast'                    : 'ast_tl',
        'pinmux.dft_strap_test'          : 'dft_strap_test'
        'pinmux.dft_hold_tap_sel'        : 'dft_hold_tap_sel',
        'pinmux.usb_dppullup_en'         : 'usb_dp_pullup_en',
        'pinmux.usb_dnpullup_en'         : 'usb_dn_pullup_en',
        'pwrmgr.pwr_ast'                 : 'pwrmgr_ast',
        'rstmgr.por_n'                   : 'por_n',
        'rstmgr.resets'                  : '',
        'rstmgr.rst_en'                  : '',
        'usbdev.usb_rx_d'                : '',
        'usbdev.usb_tx_d'                : '',
        'usbdev.usb_tx_se0'              : '',
        'usbdev.usb_tx_use_d_se0'        : '',
        'usbdev.usb_rx_enable'           : '',
        'usbdev.usb_ref_val'             : '',
        'usbdev.usb_ref_pulse'           : '',
        'spi_device.sck_monitor'         : 'sck_monitor',
    },
  },

  // Crossbars: having a top level crossbar
  // This version assumes all crossbars are instantiated at the top.
  // Assume xbar.hjson is located in the same directory of top.hjson
  xbar: [
    { name: "main",
      clock_srcs: {clk_main_i: "main", clk_fixed_i: "io_div4"},
      clock_group: "infra",
      reset: "sys",
      reset_connections: {rst_main_ni: "sys", rst_fixed_ni: "sys_io_div4"}
    },
    { name: "peri",
      clock_srcs: {clk_peri_i: "io_div4", clk_spi_host0_i: "io", clk_usb_i: "usb"},
      clock_group: "infra",
      reset: "sys_io_div4",
      reset_connections: {rst_peri_ni: "sys_io_div4", rst_spi_host0_ni: "spi_host0", rst_usb_ni: "usb"},
    }
  ],

  // Modules whose interrupts are connected to RV_PLIC.
  interrupt_module: [
    "uart0",
    "uart1",
    "gpio0",
    "spi_device",
    "spi_host0",
    // "rv_timer", connected to a dedicated interrupt input in rv_core_ibex.
    "usbdev",
    "pwrmgr",
    "aon_timer",
    "flash_ctrl",
  ]

  // ===== PINMUX & PINOUT ======================================================

  pinout: {
    // IO power bank declaration.
    // This list defines the IO bank power domains on the ASIC.
    // Each individual pad must be in one of the declared power domains.
    banks: ['VCC', 'AVCC', 'VIOA', 'VIOB'],
    // Pad declaration.
    // Each entry must have the following four keys:
    //
    // - name: Name of the pad (this will be exposed at the chiplevel).
    //
    // - type: Pad type (this maps to the pad types defined in prim_pad_wrapper_pkg.sv)
    //
    // - bank: Specifies in which of the IO power banks this pad lives.
    //
    // - connection: Can have either of the following values:
    //
    //               1) 'direct': This is a dedicated IO Pad that is directly connected to a peripheral.
    //
    //               2) 'manual': This is a dedicated IO signal that is not directly connected to a
    //                            peripheral. It needs to be manually wired up in the template.
    //
    //               3) 'muxed': This is a muxed IO pad that will be connected to the pinmux.
    //
    // Optionally, each pad can also have the following keys:
    //
    // - desc: A field for further description.
    //
    // - port_type: A field to override the default 'inout wire' type (this is currently only used
    //              for simulating ADC connections where the ports have to be switched to a real
    //              type when the ANALOGSIM macro is defined).
    //
    // Muxed and direct pads may also have:
    //
    // - attrs: This field allows to define the reset values of the MIO/DIO_PAD_ATTR CSR of direct
    //          or muxed pads. It is a dict mapping CSR field names to integer reset values. An
    //          example is: `attrs: {virtual_od_en: 1, drive_strength: 3}`
    //
    //          Fields not specified keep the default reset value of the pinmux. Whether a pad
    //          supports an attribute depends on its type and technology (WARL).
    pads: [
      // Special manually connected pads
      { name: 'POR_N'           , type: 'InputStd', bank: 'VCC' , connection: 'manual', desc: 'System reset'},
      { name: 'USB_P'           , type: 'BidirTol', bank: 'VCC' , connection: 'manual', desc: 'USB P signal'},
      { name: 'USB_N'           , type: 'BidirTol', bank: 'VCC' , connection: 'manual', desc: 'USB N signal'},
      { name: 'CC1'             , type: 'InputStd', bank: 'AVCC', connection: 'manual', desc: 'ADC input 1'},
      { name: 'CC2'             , type: 'InputStd', bank: 'AVCC', connection: 'manual', desc: 'ADC input 2'},
      { name: 'FLASH_TEST_VOLT' , type: 'AnalogIn0',bank: 'VCC' , connection: 'manual', desc: 'Flash test voltage input'},
      { name: 'FLASH_TEST_MODE0', type: 'InputStd', bank: 'VCC' , connection: 'manual', desc: 'Flash test mode signal'},
      { name: 'FLASH_TEST_MODE1', type: 'InputStd', bank: 'VCC' , connection: 'manual', desc: 'Flash test mode signal'},
      // Dedicated IOs
      { name: 'SPI_HOST_D0'     , type: 'BidirStd', bank: 'VIOA', connection: 'direct', desc: 'SPI host data'},
      { name: 'SPI_HOST_D1'     , type: 'BidirStd', bank: 'VIOA', connection: 'direct', desc: 'SPI host data'},
      { name: 'SPI_HOST_D2'     , type: 'BidirStd', bank: 'VIOA', connection: 'direct', desc: 'SPI host data'},
      { name: 'SPI_HOST_D3'     , type: 'BidirStd', bank: 'VIOA', connection: 'direct', desc: 'SPI host data'},
      { name: 'SPI_HOST_CLK'    , type: 'BidirStd', bank: 'VIOA', connection: 'direct', desc: 'SPI host clock'},
      { name: 'SPI_HOST_CS_L'   , type: 'BidirStd', bank: 'VIOA', connection: 'direct', desc: 'SPI host chip select'},
      { name: 'SPI_DEV_D0'      , type: 'BidirStd', bank: 'VIOA', connection: 'direct', desc: 'SPI device data'},
      { name: 'SPI_DEV_D1'      , type: 'BidirStd', bank: 'VIOA', connection: 'direct', desc: 'SPI device data'},
      { name: 'SPI_DEV_D2'      , type: 'BidirStd', bank: 'VIOA', connection: 'direct', desc: 'SPI device data'},
      { name: 'SPI_DEV_D3'      , type: 'BidirStd', bank: 'VIOA', connection: 'direct', desc: 'SPI device data'},
      { name: 'SPI_DEV_CLK'     , type: 'InputStd', bank: 'VIOA', connection: 'direct', desc: 'SPI device clock'},
      { name: 'SPI_DEV_CS_L'    , type: 'InputStd', bank: 'VIOA', connection: 'direct', desc: 'SPI device chip select'},
      // IOA
      { name: 'IOA0'            , type: 'BidirStd', bank: 'VIOA', connection: 'muxed' , desc: 'Muxed IO pad'},
      { name: 'IOA1'            , type: 'BidirStd', bank: 'VIOA', connection: 'muxed' , desc: 'Muxed IO pad'},
      { name: 'IOA2'            , type: 'BidirStd', bank: 'VIOA', connection: 'muxed' , desc: 'Muxed IO pad'},
      { name: 'IOA3'            , type: 'BidirStd', bank: 'VIOA', connection: 'muxed' , desc: 'Muxed IO pad'},
      { name: 'IOA4'            , type: 'BidirStd', bank: 'VIOA', connection: 'muxed' , desc: 'Muxed IO pad'},
      { name: 'IOA5'            , type: 'BidirStd', bank: 'VIOA', connection: 'muxed' , desc: 'Muxed IO pad'},
      { name: 'IOA6'            , type: 'BidirOd',  bank: 'VIOA', connection: 'muxed' , desc: 'Muxed IO pad'},
      { name: 'IOA7'            , type: 'BidirOd',  bank: 'VIOA', connection: 'muxed' , desc: 'Muxed IO pad'},
      { name: 'IOA8'            , type: 'BidirOd',  bank: 'VIOA', connection: 'muxed' , desc: 'Muxed IO pad'},
      // IOB
      { name: 'IOB0'            , type: 'BidirStd', bank: 'VIOB', connection: 'muxed' , desc: 'Muxed IO pad'},
      { name: 'IOB1'            , type: 'BidirStd', bank: 'VIOB', connection: 'muxed' , desc: 'Muxed IO pad'},
      { name: 'IOB2'            , type: 'BidirStd', bank: 'VIOB', connection: 'muxed' , desc: 'Muxed IO pad'},
      { name: 'IOB3'            , type: 'BidirStd', bank: 'VIOB', connection: 'muxed' , desc: 'Muxed IO pad'},
      { name: 'IOB4'            , type: 'BidirStd', bank: 'VIOB', connection: 'muxed' , desc: 'Muxed IO pad'},
      { name: 'IOB5'            , type: 'BidirStd', bank: 'VIOB', connection: 'muxed' , desc: 'Muxed IO pad'},
      { name: 'IOB6'            , type: 'BidirStd', bank: 'VIOB', connection: 'muxed' , desc: 'Muxed IO pad'},
      { name: 'IOB7'            , type: 'BidirStd', bank: 'VIOB', connection: 'muxed' , desc: 'Muxed IO pad'},
      { name: 'IOB8'            , type: 'BidirStd', bank: 'VIOB', connection: 'muxed' , desc: 'Muxed IO pad'},
      { name: 'IOB9'            , type: 'BidirOd' , bank: 'VIOB', connection: 'muxed' , desc: 'Muxed IO pad'},
      { name: 'IOB10'           , type: 'BidirOd' , bank: 'VIOB', connection: 'muxed' , desc: 'Muxed IO pad'},
      { name: 'IOB11'           , type: 'BidirOd' , bank: 'VIOB', connection: 'muxed' , desc: 'Muxed IO pad'},
      { name: 'IOB12'           , type: 'BidirOd' , bank: 'VIOB', connection: 'muxed' , desc: 'Muxed IO pad'},
      // IOC
      { name: 'IOC0'            , type: 'BidirStd', bank: 'VCC' , connection: 'muxed' , desc: 'Muxed IO pad'},
      { name: 'IOC1'            , type: 'BidirStd', bank: 'VCC' , connection: 'muxed' , desc: 'Muxed IO pad'},
      { name: 'IOC2'            , type: 'BidirStd', bank: 'VCC' , connection: 'muxed' , desc: 'Muxed IO pad'},
      { name: 'IOC3'            , type: 'BidirStd', bank: 'VCC' , connection: 'muxed' , desc: 'Muxed IO pad'},
      { name: 'IOC4'            , type: 'BidirStd', bank: 'VCC' , connection: 'muxed' , desc: 'Muxed IO pad'},
      { name: 'IOC5'            , type: 'BidirStd', bank: 'VCC' , connection: 'muxed' , desc: 'Muxed IO pad'},
      { name: 'IOC6'            , type: 'BidirStd', bank: 'VCC' , connection: 'muxed' , desc: 'Muxed IO pad'},
      { name: 'IOC7'            , type: 'BidirStd', bank: 'VCC' , connection: 'muxed' , desc: 'Muxed IO pad'},
      // Enable pull-down to ensure TAP strap 0 gets sampled as 0 unless driven to 1 from an external source
      // (and specifically that it gets sampled as 0 when left floating / not connected).
      { name: 'IOC8'            , type: 'BidirStd', bank: 'VCC' , connection: 'muxed' , desc: 'Muxed IO pad', attrs: {pull_en: 1}},
      { name: 'IOC9'            , type: 'BidirStd', bank: 'VCC' , connection: 'muxed' , desc: 'Muxed IO pad'},
      { name: 'IOC10'           , type: 'BidirOd' , bank: 'VCC' , connection: 'muxed' , desc: 'Muxed IO pad'},
      { name: 'IOC11'           , type: 'BidirOd' , bank: 'VCC' , connection: 'muxed' , desc: 'Muxed IO pad'},
      { name: 'IOC12'           , type: 'BidirOd' , bank: 'VCC' , connection: 'muxed' , desc: 'Muxed IO pad'},
      // IOR
      { name: 'IOR0'            , type: 'BidirStd', bank: 'VCC' , connection: 'muxed' , desc: 'Muxed IO pad'},
      { name: 'IOR1'            , type: 'BidirStd', bank: 'VCC' , connection: 'muxed' , desc: 'Muxed IO pad'},
      { name: 'IOR2'            , type: 'BidirStd', bank: 'VCC' , connection: 'muxed' , desc: 'Muxed IO pad'},
      { name: 'IOR3'            , type: 'BidirStd', bank: 'VCC' , connection: 'muxed' , desc: 'Muxed IO pad'},
      { name: 'IOR4'            , type: 'BidirStd', bank: 'VCC' , connection: 'muxed' , desc: 'Muxed IO pad'},
      { name: 'IOR5'            , type: 'BidirStd', bank: 'VCC' , connection: 'muxed' , desc: 'Muxed IO pad'},
      { name: 'IOR6'            , type: 'BidirStd', bank: 'VCC' , connection: 'muxed' , desc: 'Muxed IO pad'},
      { name: 'IOR7'            , type: 'BidirStd', bank: 'VCC' , connection: 'muxed' , desc: 'Muxed IO pad'},
      { name: 'IOR10'           , type: 'BidirOd' , bank: 'VCC' , connection: 'muxed' , desc: 'Muxed IO pad'},
      { name: 'IOR11'           , type: 'BidirOd' , bank: 'VCC' , connection: 'muxed' , desc: 'Muxed IO pad'},
      { name: 'IOR12'           , type: 'BidirOd' , bank: 'VCC' , connection: 'muxed' , desc: 'Muxed IO pad'},
      { name: 'IOR13'           , type: 'BidirOd' , bank: 'VCC' , connection: 'muxed' , desc: 'Muxed IO pad'},
    ]
  }

  pinmux: {
    // Signal to pinmux/pad mapping.
    // Each entry in the list below must have the following three mandatory keys:
    //
    // - instance: This is the comportable IO instance name where the IO signal comes from.
    //
    // - connection: This key is similar to the connection key in the pinout/pad configuration and
    //               can have either of the following values:
    //
    //               1) 'direct': This is a dedicated IO signal that is directly connected to a pad.
    //                            Such an IO signal must also specify the 'port' key and exactly
    //                            one pad in 'pads' (see further below).
    //
    //               2) 'manual': This is a dedicated IO signal that is not directly connected to a pad.
    //                            It needs to be manually wired up in the template.
    //                            Such an IO signal may have a 'port' key and must have an empty
    //                            'pads'.
    //
    //               3) 'muxed': This is a muxed IO signal that will be connected to the pinmux.
    //                           Such an IO signal may have a 'port' key.
    //
    // - pads: Required list of pad names. The content depends on the connection type:
    //         direct: Exactly one entry, the direct pad this signal is connected to.
    //         manual: No meaning. Must be an empty list.
    //         muxed:  Restricts the muxing to the listed muxed pads. An empty list means that the
    //                 signal can be muxed to all muxed pads and all pads can be muxed to this
    //                 signal. The muxing constraint also depends on the direction of the signal:
    //                 - Input:  defines the pads this signal can select (INSEL).
    //                 - Output: defines the pads that can select this signal (OUTSEL).
    //                 - Inout:  defines both directions at once.
    //
    //                 If 'port' is empty, the list applies to all ports of the instance.
    //
    // Depending on the connection type specified, each entry may have the following optional keys:
    //
    // - port: Name of the available IO signal of the instance.
    //         This is required for 'direct' connections, but optional for the others.
    //         Individual signals of a bus IO signal must be indexed with square brackets, e.g. mybus[1].
    //         Not specifying this key or setting it to an empty string acts as a wild card
    //         and includes all available IOs of this instance.
    //
    // - default: Defines the muxing at reset of a muxed signal, i.e., the reset values of the INSEL
    //            and OUTSEL registers. Only muxed connections may have this key. The possible
    //            values depend on the signal direction:
    //
    //            If input:  Defines the INSEL reset value for this signal. Possible defaults are:
    //                       - a pad name (string): Signal is connected to this pad at reset.
    //                       - 0 or 1 (int):        Signal is driven to '0 or '1 at reset.
    //
    //                       If default is not specified, the signal is driven to '0.
    //
    //            If output: The value must be a pad name. If given, this pad is then driven by
    //                       this signal after reset (defines the OUTSEL reset value for this pad).
    //                       Each pad may only be referenced once in the complete 'signals' list as
    //                       a default pad.
    //
    //                       If a pad is never specified as a default, the pad is set to high-Z at
    //                       reset.
    //
    //            If inout:  Defines the INSEL and OUTSEL reset values for this signal and pad.
    //                       Possible defaults are:
    //                       - a pad name (string): Signal is connected to this pad at reset and the
    //                                              pad's default output is this signal.
    //                       - 0 or 1 (int):        Signal is driven to '0 or '1 at reset. Imposes
    //                                              no default source for any pad.
    //
    //                       If this default is not specified, the signal is driven to '0 and no pad
    //                       default is derived.
    //
    // - follower: Only allowed for muxed 1-bit input or bidir signals. A string naming another
    //             comportable input which is controlled by the same INSEL CSR, decoded as
    //             'instance.port'. The follower must always be a 1-bit input and must not have
    //             its own signal entry. It gets no INSEL CSR of its own.
    //
    //             This allows controlling with one INSEL CSR the muxing of signals which go to
    //             different IPs or partitions of an IP. Examples are the reset detector signals
    //             for I3C. These must always follow SCL/SDA and the muxing must also be active in
    //             deep sleep. Defining the reset detector signals as followers of SCL/SDA ensures
    //             they always stay in sync. It also ensures that the muxing is active in deep
    //             sleep as in this particular case the muxing is duplicated in both pinmux
    //             partitions.
    //
    //             An empty string generates the INSEL mux of this signal in both partitions, so
    //             both partitions provide the mux result. This is useful when directly tapping
    //             into the mux results, see for example the USB wakeup detector inside the
    //             pinmux.
    //
    // - desc: Optional description field.
    //
    // - attr: Manual direct IOs may specify an additional pad attr field.
    //         This is used to create the correct pad attribute CSR for that DIO channel (since the
    //         DIO is manual, there is no way to automatically infer the corresponding pad type).
    //         Not to be confused with the 'attrs' key of a pad.
    //
    signals: [
      // SPI Host0
      { instance: 'spi_host0',       port: 'sck',   connection: 'direct', pads: ['SPI_HOST_CLK']  , desc: ''},
      { instance: 'spi_host0',       port: 'csb',   connection: 'direct', pads: ['SPI_HOST_CS_L'] , desc: ''},
      { instance: 'spi_host0',       port: 'sd[0]', connection: 'direct', pads: ['SPI_HOST_D0']   , desc: ''},
      { instance: 'spi_host0',       port: 'sd[1]', connection: 'direct', pads: ['SPI_HOST_D1']   , desc: ''},
      { instance: 'spi_host0',       port: 'sd[2]', connection: 'direct', pads: ['SPI_HOST_D2']   , desc: ''},
      { instance: 'spi_host0',       port: 'sd[3]', connection: 'direct', pads: ['SPI_HOST_D3']   , desc: ''},
      // SPI Device
      { instance: 'spi_device',      port: 'sck',   connection: 'direct', pads: ['SPI_DEV_CLK']   , desc: ''},
      { instance: 'spi_device',      port: 'csb',   connection: 'direct', pads: ['SPI_DEV_CS_L']  , desc: ''},
      { instance: 'spi_device',      port: 'sd[0]', connection: 'direct', pads: ['SPI_DEV_D0']    , desc: ''},
      { instance: 'spi_device',      port: 'sd[1]', connection: 'direct', pads: ['SPI_DEV_D1']    , desc: ''},
      { instance: 'spi_device',      port: 'sd[2]', connection: 'direct', pads: ['SPI_DEV_D2']    , desc: ''},
      { instance: 'spi_device',      port: 'sd[3]', connection: 'direct', pads: ['SPI_DEV_D3']    , desc: ''},
      // USBDEV
      { instance: 'usbdev',          port: 'usb_dp', connection: 'manual', pads: []               , desc: ''},
      { instance: 'usbdev',          port: 'usb_dn', connection: 'manual', pads: []               , desc: ''},
      // MIOs
      { instance: "gpio0",           port: '',      connection: 'muxed' , pads: []                , desc: ''},
      { instance: "uart0",           port: '',      connection: 'muxed' , pads: []                , desc: ''},
      { instance: "uart1",           port: '',      connection: 'muxed' , pads: []                , desc: ''},
      { instance: "flash_ctrl",      port: '',      connection: 'muxed' , pads: []                , desc: ''},
      { instance: 'usbdev',          port: 'sense', connection: 'muxed' , pads: []                , desc: ''},
    ],

    // Number of wakeup detectors to instantiate, and bitwidth for the wakeup counters.
    num_wkup_detect: 8
    wkup_cnt_width:  8
    // Enable USB wakeup and hardware strap sampling for discrete OpenTitan
    enable_usb_wakeup: true
    enable_strap_sampling: true
  }

  // Implementation targets.
  // This defines the configuration of the target-specific chip-levels  to
  // generate from the shared template. Each target uses the same base
  // configuration for the  pinmux and pinout as defined above, and the
  // generated software constants for the pinmux DIF do not change among the
  // implementation targets. However, in order to accommodate slight
  // differences among the ASIC, FPGA emulation and simulation environments,
  // it is possible to make very limited pinout changes below. In particular,
  // it is possible to remove and tie-off specific pads, or add more 'manual'
  // pads that need to be manually connected in the template. It is also possible
  // to override the JTAG and strap locations indices, since the testing and DFT
  // setups may differ among the targets.
  targets: [
    { name: 'cw305',

      // Chip level changes
      chiplevel: {
        port_overrides: {
          'pinmux.dft_hold_tap_sel'        : { unused: true },
          'pinmux.dft_strap_test'          : { unused: true },
          'pinmux.usb_dppullup_en'         : { signal: 'usb_dp_pullup_en' },
          'pinmux.usb_dnpullup_en'         : { signal: 'usb_dn_pullup_en' },
          'clkmgr.cg_en'                   : { unused: true },
          'rstmgr.rst_en'                  : { unused: true },
          'usbdev.usb_tx_d'                : { unused: true },
          'usbdev.usb_tx_se0'              : { unused: true },
          'usbdev.usb_tx_use_d_se0'        : { unused: true },
          'usbdev.usb_rx_d'                : { unused: true },
          'usbdev.usb_rx_enable'           : { unused: true },
          'usbdev.usb_ref_val'             : { signal: 'usb_ref_val'   },
          'usbdev.usb_ref_pulse'           : { signal: 'usb_ref_pulse' },
          'flash_ctrl.flash_power_down_h'  : { unused: true },
          'flash_ctrl.flash_power_ready_h' : { unused: true, tie_value: "1'b1" },
        }
      }

      pinout: {
        remove_ports: [],
        remove_pads: [
          'CC1', 'CC2',
          'SPI_DEV_D2', 'SPI_DEV_D3'
          'SPI_HOST_CLK', 'SPI_HOST_CS_L',
          'SPI_HOST_D0', 'SPI_HOST_D1', 'SPI_HOST_D2', 'SPI_HOST_D3',
          'FLASH_TEST_VOLT',
          'FLASH_TEST_MODE0', 'FLASH_TEST_MODE1',
          'IOB7', 'IOB8', 'IOB9', 'IOB10', 'IOB11', 'IOB12',
          'IOC6', 'IOC7', 'IOC9', 'IOC10', 'IOC11', 'IOC12',
          'IOR0', 'IOR1', 'IOR2', 'IOR3', 'IOR5', 'IOR6', 'IOR7', 'IOR10', 'IOR11', 'IOR12', 'IOR13'
        ],

        add_pads: [
          // Additional infrastructure pads
          { name: 'IO_CLK',           type: 'InputStd', bank: 'VCC', connection: 'manual', desc: 'Extra clock input for FPGA target'}
          { name: 'POR_BUTTON_N',     type: 'InputStd', bank: 'VCC', connection: 'manual', desc: 'POR from the push-button'}
          // Custom USB pads
          { name: 'IO_USB_SENSE0',    type: 'BidirStd', bank: 'VCC', connection: 'manual', desc: 'Manual USB signal for FPGA target'}
          { name: 'IO_USB_DNPULLUP0', type: 'BidirStd', bank: 'VCC', connection: 'manual', desc: 'Manual USB signal for FPGA target'}
          { name: 'IO_USB_DPPULLUP0', type: 'BidirStd', bank: 'VCC', connection: 'manual', desc: 'Manual USB signal for FPGA target'}
          // ChipWhisperer IO
          { name: 'IO_CLKOUT',        type: 'BidirStd', bank: 'VCC', connection: 'manual', desc: 'Manual clock output for SCA setup'}
          { name: 'IO_TRIGGER',       type: 'BidirStd', bank: 'VCC', connection: 'manual', desc: 'Manual trigger output for SCA setup'}
        ],
      }

      pinmux: {
        special_signals: [
          // Straps
          // Check pad attributes if strap pins change.
          { name: 'tap0',   pad: 'IOC8',         desc: 'TAP strap signal.'                       },
          { name: 'tap1',   pad: 'IOC5',         desc: 'TAP strap signal.'                       },
          { name: 'dft0',   pad: 'IOR5',         desc: 'DFT strap signal.'                       },
          { name: 'dft1',   pad: 'IOR7',         desc: 'DFT strap signal.'                       },
          // JTAG
          { name: 'tck',    pad: 'SPI_DEV_CLK' , desc: 'JTAG tck signal, overlaid on SPI_DEV.'   },
          { name: 'tms',    pad: 'SPI_DEV_CS_L', desc: 'JTAG tms signal, overlaid on SPI_DEV.'   },
          { name: 'trst_n', pad: 'IOR4',         desc: 'JTAG trst_n signal.'                     },
          { name: 'tdi',    pad: 'SPI_DEV_D0'  , desc: 'JTAG tdi signal, overlaid on SPI_DEV.'   },
          { name: 'tdo',    pad: 'SPI_DEV_D1'  , desc: 'JTAG tdo signal, overlaid on SPI_DEV.'   },
        ],
      }
    },
    { name: 'verilator',

      // The verilator chip-level has no physical pads: The flat per-peripheral
      // signals are connected to the testbench DPI models through the
      // padring_verilator module. As in the earlgrey verilator target, only the
      // USB signals observed/driven by the usbdpi model are overridden; all
      // other signals (incl. the USB Dn pull-up, the DFT strap test bus and the
      // AST-driven flash power controls) flow through the common ASIC path so
      // they are driven/consumed identically to the earlgrey verilator top.
      chiplevel: {
        port_overrides: {
          'pinmux.dft_hold_tap_sel' : { unused: true              },
          'pinmux.usb_dppullup_en'  : { signal: 'usb_dp_pullup_en'},
          'pinmux.usb_dnpullup_en'  : { signal: 'usb_dn_pullup_en'},
          'clkmgr.cg_en'            : { unused: true              },
          'rstmgr.rst_en'           : { unused: true              },
          'usbdev.usb_rx_d'         : { signal: 'usb_rx_d'        },
          'usbdev.usb_rx_enable'    : { signal: 'usb_rx_enable'   },
          'usbdev.usb_tx_d'         : { signal: 'usb_tx_d'        },
          'usbdev.usb_tx_se0'       : { signal: 'usb_tx_se0'      },
          'usbdev.usb_tx_use_d_se0' : { signal: 'usb_tx_use_d_se0'},
          'usbdev.usb_ref_val'      : { signal: 'usb_ref_val'     },
          'usbdev.usb_ref_pulse'    : { signal: 'usb_ref_pulse'   },
        }
      }

      // The verilator target has no physical pads, so there is nothing to
      // remove or add here.
      pinout: {
        remove_ports: [],
        remove_pads: [],
        add_pads: [],
      }

      pinmux: {
        // Same special signal (JTAG / strap) positions as the cw305 target.
        special_signals: [
          // Straps
          // Check pad attributes if strap pins change.
          { name: 'tap0',   pad: 'IOC8',         desc: 'TAP strap signal.'                       },
          { name: 'tap1',   pad: 'IOC5',         desc: 'TAP strap signal.'                       },
          { name: 'dft0',   pad: 'IOR5',         desc: 'DFT strap signal.'                       },
          { name: 'dft1',   pad: 'IOR7',         desc: 'DFT strap signal.'                       },
          // JTAG
          { name: 'tck',    pad: 'SPI_DEV_CLK' , desc: 'JTAG tck signal, overlaid on SPI_DEV.'   },
          { name: 'tms',    pad: 'SPI_DEV_CS_L', desc: 'JTAG tms signal, overlaid on SPI_DEV.'   },
          { name: 'trst_n', pad: 'IOR4',         desc: 'JTAG trst_n signal.'                     },
          { name: 'tdi',    pad: 'SPI_DEV_D0'  , desc: 'JTAG tdi signal, overlaid on SPI_DEV.'   },
          { name: 'tdo',    pad: 'SPI_DEV_D1'  , desc: 'JTAG tdo signal, overlaid on SPI_DEV.'   },
        ],
      }
    }
  ]
}
