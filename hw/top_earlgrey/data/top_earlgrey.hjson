// Copyright lowRISC contributors (OpenTitan project).
// Licensed under the Apache License, Version 2.0, see LICENSE for details.
// SPDX-License-Identifier: Apache-2.0
//
// TOP Earlgrey configuration
{ name: "earlgrey",
  type: "top",

  // 32-bit datawidth
  datawidth: "32",

  // Power information for the design
  power: {
    // Power domains supported by the design
    domains: ["Aon", "Main"],

    // Default power domain used for the design
    default: "Main"

    // Discrete OpenTitan does not need to wait for external resets
    wait_for_external_reset: false
  },

  // List of unmanaged external clocks
  unmanaged_clocks: [
    { name: "ast_ext" } // TODO: this generates a cg_en which is not used. should we fall back to a regular port?
  ]

  // This is the clock data structure of the design.
  // The src key indicates the raw clock sources in the design. These are
  // routed to the clkmgr which then gates them and generates the derived
  // clocks.
  // The groups key indicates the various clock groupings in the design.
  clocks: {

    // Clock Source attributes
    // name: Name of group.
    // aon:  Whether the clock is free running all the time.
    //       If it is, the clock is not handled by clkmgr.
    // freq: Absolute frequency of clk in Hz
    // ref: indicates the clock is used as a reference for measurement.
    //
    // If the clock is not provided externally to the top, define which
    // internal module generates the raw clock by setting:
    // module: The module that generates the clock.
    // signal: The signal name of the clock source in the module.
    // partition: The partition of the module that generates the clock.
    srcs: [
      { name: "main", aon: "no",  freq: "100000000",
        module: "ast", signal: "clk_src_sys", partition: "primary" },
      { name: "io",   aon: "no",  freq: "96000000",
        module: "ast", signal: "clk_src_io",  partition: "primary" },
      { name: "usb",  aon: "no",  freq: "48000000",
        module: "ast", signal: "clk_src_usb", partition: "primary" },
      { name: "aon",  aon: "yes", freq: "200000", ref: true,
        module: "ast", signal: "clk_src_aon", partition: "secondary" }
    ],

    // Derived clock source attributes
    // name: Name of group.
    // aon:  Whether the clock is free running all the time.
    //       If it is, the clock is not handled by clkmgr.
    // freq: Absolute frequency of clk in Hz
    // src:  From which clock source is the clock derived
    // div:  Ratio between derived clock and source clock
    derived_srcs: [
      { name: "io_div4", aon: "no", div: 4, src: "io", freq: "24000000" }
    ],

    // Clock Group attributes
    // name: name of group.
    //
    // src: The hierarchical source of the clock
    // "ext"  - clock is supplied from a port of the top module
    // "top"  - clock is supplied from a net inside the top module
    //
    // sw_cg: whether software is allowed to gate the clock
    // "no"   - software is not allowed to gate clocks
    // "yes"  - software is allowed to gate clocks
    // "hint" - software can provide a hint, and hw controls the rest
    //
    // unique: whether each module in the group can be separately gated
    //         if sw_cg is "no", this field has no meaning
    // "yes"  - each clock is individually controlled
    // "no"   - the group is controlled as one single unit
    //
    // The powerup and proc groups are unique.
    // The powerup group of clocks do not feed through the clock
    // controller as they manage clock controller behavior
    // The proc group is not peripheral, and directly hardwired
    //
    // The group containing the raw clocks driving the clkmgr must have
    // src: "ext", even if these clocks are generated inside the top.
    // Otherwise topgen drives the clkmgr with clocks controlled by
    // itself. This is not possible. This group must also be exclusively used
    // by the clkmgr and not by any other module.

    groups: [
      // the powerup group is used exclusively by clk/pwr/rstmgr/pinmux
      { name: "ast",       src:"ext", sw_cg: "no"                   },
      { name: "powerup",   src:"top", sw_cg: "no"                   },
      { name: "trans",     src:"top", sw_cg: "hint", unique: "yes", },
      { name: "infra",     src:"top", sw_cg: "no",                  },
      { name: "secure",    src:"top", sw_cg: "no"                   },
      { name: "peri",      src:"top", sw_cg: "yes",  unique: "no"   },
      // SPI_HOST1 has its own software-controlled clock gate, separate from
      // that of SPI_HOST0 (peri group), so software can turn off either host.
      { name: "spi_host1", src:"top", sw_cg: "yes",  unique: "no"   },
      { name: "timers",    src:"top", sw_cg: "no"                   }
    ],
  },

  // List of unmanaged external resets
  //
  // These should be listed as dictionaries that just give their names, in this form:
  //
  //    { name: "my_external_reset" }
  // unmanaged_resets: []

  // This is the reset data structure of the design.
  // The node key represents all the known resets in the design
  resets: {

    // Reset node attributes
    // name: name of reset.
    //
    // gen: whether the reset is generated
    // true: it is a generated reset inside rstmgr
    // false: it is a hardwired design reset inside rstmgr (roots and por)
    // For non-generated resets, the parent / domain definitions have no meaning.
    //
    // type: the reset type [ext, top]
    // ext: the reset is coming in from the ports, external to earlgrey
    // int: the reset is only used inside rstmgr
    // top: the reset is output from rstmgr to top level struct
    //
    // parent: The parent reset
    // If type is "ext", there is no root, since it is external
    //
    // domains: The power domains of a particular reset
    // This is a list of the supported power domains.
    // Valid values are Aon and (power domain)0 ~ (power domain)1.
    // If no value is supplied, the default is specified by the power configuration.
    //
    // clk:  related clock domain for synchronous release
    // If type is "por", there is not related clock, since it is
    // likely external or generated from a voltage comparator
    //
    nodes: [
      { name: "por_aon",        gen: false, type: "top",                    clock: "aon"     },
      { name: "lc_src",         gen: false, type: "int",                    clock: "io_div4" },
      { name: "sys_src",        gen: false, type: "int",                    clock: "io_div4" },
      { name: "por",            gen: true,  type: "top", parent: "por_aon", clock: "main"    },
      { name: "por_io",         gen: true,  type: "top", parent: "por_aon", clock: "io"      },
      { name: "por_io_div4",    gen: true , type: "top", parent: "por_aon", clock: "io_div4" },
      { name: "por_usb",        gen: true , type: "top", parent: "por_aon", clock: "usb" },
      { name: "lc",             gen: true,  type: "top", parent: "lc_src",  clock: "main"    },
      { name: "lc_aon",         gen: true,  type: "top", parent: "lc_src",  clock: "aon"     },
      { name: "lc_io",          gen: true,  type: "top", parent: "lc_src",  clock: "io"      },
      { name: "lc_io_div4",     gen: true,  type: "top", parent: "lc_src",  clock: "io_div4" },
      { name: "lc_usb",         gen: true,  type: "top", parent: "lc_src",  clock: "usb"     },
      { name: "sys",            gen: true,  type: "top", parent: "sys_src", clock: "main"    },
      { name: "sys_io_div4",    gen: true,  type: "top", parent: "sys_src", clock: "io_div4" },
      { name: "spi_device",     gen: true,  type: "top", parent: "lc_src", clock: "io_div4", sw: true },
      { name: "spi_host0",      gen: true,  type: "top", parent: "lc_src", clock: "io",      sw: true },
      { name: "spi_host1",      gen: true,  type: "top", parent: "lc_src", clock: "io",      sw: true },
      { name: "usb",            gen: true,  type: "top", parent: "lc_src", clock: "usb",     sw: true },
      { name: "usb_aon",        gen: true,  type: "top", parent: "lc_src", clock: "aon",     sw: true },
      { name: "i2c0",           gen: true,  type: "top", parent: "lc_src", clock: "io_div4", sw: true },
      { name: "i2c1",           gen: true,  type: "top", parent: "lc_src", clock: "io_div4", sw: true },
      { name: "i2c2",           gen: true,  type: "top", parent: "lc_src", clock: "io_div4", sw: true },
      { name: "i3c0",           gen: true,  type: "top", parent: "lc_src", clock: "io",      sw: true },
      { name: "i3c1",           gen: true,  type: "top", parent: "lc_src", clock: "io",      sw: true },
    ]
  },
  // The reset requests: peripherals are deduced, but internal and debug need
  // to be configure in hjson file.
  reset_requests: {
    int: [
      {
        "name": "MainPwr",
        "desc": "main power glitch reset request",
        "module": "pwrmgr"
      },
      {
        "name": "Esc",
        "desc": "escalation reset request",
        "module": "alert_handler"
      }
    ],
    debug: [
      {
        "name": "Ndm",
        "desc": "non-debug-module reset request",
        "module": "rv_dm"
      }
    ],
  },
  // Number of cores: used in rv_plic and timer
  num_cores: "1",

  // Any module with interrupts that doesn't specify plic
  // will have its interrupts sent here
  default_plic: "rv_plic"

  // Any module with alerts that doesn't specify alert_handler
  // will have its alerts sent here
  default_alert_handler: "alert_handler"

  // `addr_spaces` names the distinct address spaces present in the device.
  // All hosts in the same address space share the same base addresses for
  // all peripherals, though not every peripheral will be accessible to every
  // host in that address space--Access privileges are separate from addresses.
  addr_spaces: [
    { name: "hart",
      desc: "The main address space, shared between the CPU and DM"
      subspaces: [
        { name: "mmio",
          desc: '''
                MMIO region excludes any memory that is separate from the module configuration
                space, i.e. ROM, main SRAM, and RRAM are excluded but retention SRAM, spi_device
                memory, or usbdev memory are included.
                '''
          nodes: [
            "uart0",
            "uart1",
            "uart2",
            "uart3",
            "gpio0",
            "gpio1",
            "spi_device",
            "i2c0",
            "i2c1",
            "i2c2",
            "i3c0",
            "i3c1",
            "rv_timer"
            "otp_ctrl",
            "lc_ctrl.regs",
            "alert_handler",
            "spi_host0",
            "spi_host1",
            "usbdev",
            "pwrmgr",
            "rstmgr",
            "clkmgr",
            "sysrst_ctrl",
            "adc_ctrl",
            "pinmux",
            "aon_timer",
            "ast",
            "sensor_ctrl",
            "sram_ctrl_ret",
            "rram_ctrl.core"
            "rram_macro.prim"
            "rv_plic",
            "aes",
            "hmac",
            "kmac",
            "otbn",
            "keymgr_dpe",
            "csrng",
            "entropy_src",
            "edn0"
            "edn1",
            "sram_ctrl_main.regs",
            "sram_ctrl_sec.regs",
            "sram_ctrl_meta.regs",
            "rom_ctrl.regs",
            "rv_core_ibex",
            "cheriot_mem_sys.regs"
          ]
        }
      ]
    },
  ]

  // `module` defines the peripherals.
  // Details are coming from each modules' config file `ip.hjson`
  // TODO: Define parameter here
  // attr: There are a few types of modules supported
     //   normal(default): Normal, non-templated modules that will be instantiated
     //   templated:   These modules are templated and must be run through topgen
     //   ipgen:       These modules are the same as templated but use the new ipgen flow
     //   reggen_top:  These modules are not templated, but need to have reggen run
     //                because they live exclusively in hw/top_* instead of hw/ip_*.
     //                These modules are also instantiated in the top level.
     //   reggen_only: Similar to reggen_top, but are not instantiated in the top level.
  module: [
    { name: "uart0",    // instance name
      type: "uart",     // Must be matched to the ip name in `ip.hjson` (_reg, _cfg permitted)
                        // and `hw/ip/{type}`

      // clock connections defines the port to top level clock connection
      // the ip.hjson will declare the clock port names
      // If none are defined at ip.hjson, clk_i is used by default
      clock_srcs: {clk_i: "io_div4"},
      clock_group: "peri",
      // reset connections defines the port to top level reset connection
      // the ip.hjson will declare the reset port names
      // If none are defined at ip.hjson, rst_ni is used by default
      reset_connections: {rst_ni: "lc_io_div4"},
      base_addr: {
        hart: "0x40000000",
      },
    },
    { name: "uart1",    // instance name
      type: "uart",     // Must be matched to the ip name in `ip.hjson` (_reg, _cfg permitted)
                        // and `hw/ip/{type}`

      // clock connections defines the port to top level clock connection
      // the ip.hjson will declare the clock port names
      // If none are defined at ip.hjson, clk_i is used by default
      clock_srcs: {clk_i: "io_div4"},
      clock_group: "peri",
      // reset connections defines the port to top level reset connection
      // the ip.hjson will declare the reset port names
      // If none are defined at ip.hjson, rst_ni is used by default
      reset_connections: {rst_ni: "lc_io_div4"},
      base_addr: {
        hart: "0x40010000",
      },
    },
    { name: "uart2",    // instance name
      type: "uart",     // Must be matched to the ip name in `ip.hjson` (_reg, _cfg permitted)
                        // and `hw/ip/{type}`

      // clock connections defines the port to top level clock connection
      // the ip.hjson will declare the clock port names
      // If none are defined at ip.hjson, clk_i is used by default
      clock_srcs: {clk_i: "io_div4"},
      clock_group: "peri",
      // reset connections defines the port to top level reset connection
      // the ip.hjson will declare the reset port names
      // If none are defined at ip.hjson, rst_ni is used by default
      reset_connections: {rst_ni: "lc_io_div4"},
      base_addr: {
        hart: "0x40020000",
      },
    },
    { name: "uart3",    // instance name
      type: "uart",     // Must be matched to the ip name in `ip.hjson` (_reg, _cfg permitted)
                        // and `hw/ip/{type}`

      // clock connections defines the port to top level clock connection
      // the ip.hjson will declare the clock port names
      // If none are defined at ip.hjson, clk_i is used by default
      clock_srcs: {clk_i: "io_div4"},
      clock_group: "peri",
      // reset connections defines the port to top level reset connection
      // the ip.hjson will declare the reset port names
      // If none are defined at ip.hjson, rst_ni is used by default
      reset_connections: {rst_ni: "lc_io_div4"},
      base_addr: {
        hart: "0x40030000",
      },
    },
    { name: "gpio0",
      type: "gpio",
      template_type: "gpio",
      clock_srcs: {clk_i: "io_div4"},
      clock_group: "peri",
      reset_connections: {rst_ni: "lc_io_div4"},
      base_addr: {
        hart: "0x40040000",
      },
      param_decl: {
        GpioAsHwStrapsEn: "0",
        GpioAsyncOn: "1"
      },
      ipgen_params: {
        per_pin_view: true
      }
      attr: "ipgen"
    },
    { name: "gpio1",
      type: "gpio",
      template_type: "gpio",
      clock_srcs: {clk_i: "io_div4"},
      clock_group: "peri",
      reset_connections: {rst_ni: "lc_io_div4"},
      base_addr: {
        hart: "0x40050000",
      },
      param_decl: {
        GpioAsHwStrapsEn: "0",
        GpioAsyncOn: "1"
      },
      // The ipgen parameters must exactly match the parameters of gpio0. Topgen only supports
      // rendering one version of a templated IP.
      ipgen_params: {
        per_pin_view: true
      }
      attr: "ipgen"
    },
    { name: "spi_device",
      type: "spi_device",
      clock_srcs: {clk_i: "io_div4", scan_clk_i: "io_div4"},
      clock_group: "peri",
      reset_connections: {rst_ni: "spi_device"},
      base_addr: {
        hart: "0x40060000",
      },
      param_decl: {
        "SramType": "spi_device_pkg::SramType1r1w"
      }
    },
    { name: "i2c0",
      type: "i2c",
      clock_srcs: {clk_i: "io_div4"},
      clock_group: "peri",
      reset_connections: {rst_ni: "i2c0"},
      base_addr: {
        hart: "0x40080000",
      },
    },
    { name: "i2c1",
      type: "i2c",
      clock_srcs: {clk_i: "io_div4"},
      clock_group: "peri",
      reset_connections: {rst_ni: "i2c1"},
      base_addr: {
        hart: "0x40090000",
      },
    },
    { name: "i2c2",
      type: "i2c",
      clock_srcs: {clk_i: "io_div4"},
      clock_group: "peri",
      reset_connections: {rst_ni: "i2c2"},
      base_addr: {
        hart: "0x400A0000",
      },
    },
    { name: "i3c0",
      type: "i3c",
      clock_srcs: {
        primary: {clk_i: "io", clk_aon_i: "aon", scan_clk_i: "io_div4"},
        secondary: {clk_aon_i: "aon"},
      },
      clock_group: {primary: "peri", secondary: "peri"},
      reset_connections: {
        primary: {rst_ni: "i3c0", rst_aon_ni: "lc_aon"},
        secondary: {rst_aon_ni: {name: "lc_aon", domain: "Aon"}},
      },
      domain: "Main",
      domain_secondary: "Aon",
      base_addr: {
        hart: "0x40330000",
      },
      param_decl: {
        ClkFreq: "96000000",
        HalfCycleScl: "1",
        NumTargets: "2"
      },
    },
    { name: "i3c1",
      type: "i3c",
      clock_srcs: {
        primary: {clk_i: "io", clk_aon_i: "aon", scan_clk_i: "io_div4"},
        secondary: {clk_aon_i: "aon"},
      },
      clock_group: {primary: "peri", secondary: "peri"},
      reset_connections: {
        primary: {rst_ni: "i3c1", rst_aon_ni: "lc_aon"},
        secondary: {rst_aon_ni: {name: "lc_aon", domain: "Main"}},
      },
      domain: "Main",
      domain_secondary: "Main",
      base_addr: {
        hart: "0x40340000",
      },
      param_decl: {
        ClkFreq: "96000000",
        HalfCycleScl: "1",
        NumTargets: "2"
      },
    },
    { name: "rv_timer",
      type: "rv_timer",
      clock_srcs: {clk_i: "io_div4"},
      clock_group: "timers",
      reset_connections: {rst_ni: "lc_io_div4"},
      base_addr: {
        hart: "0x40100000",
      },
    },
    { name: "otp_ctrl",
      type: "otp_ctrl",
      template_type: "otp_ctrl",
      clock_srcs: {clk_i: "io_div4", clk_edn_i: "main"},
      clock_group: "secure",
      reset_connections: {rst_ni: "lc_io_div4", rst_edn_ni: "lc"},
      base_addrs: {
        core: {hart: "0x40130000"},
      }
      attr: "ipgen"
      // One key slot each for sram_ctrl_main, sram_ctrl_sec, sram_ctrl_ret,
      // sram_ctrl_meta and the Ibex icache.
      ipgen_params: {
        num_sram_key_req_slots: 5
      }
    },
    { name: "lc_ctrl",
      type: "lc_ctrl",
      clock_srcs: {clk_i: "io_div4", clk_kmac_i: "main"},
      clock_group: "secure",
      reset_connections: {rst_ni: "lc_io_div4", rst_kmac_ni: "lc"},
      base_addrs: {
        regs: {hart: "0x40140000"},
      },
      param_decl: {
        // NOTE THAT THIS IS A FEATURE FOR TEST CHIPS ONLY TO MITIGATE
        // THE RISK OF A BROKEN OTP MACRO. THIS WILL BE DISABLED FOR
        // PRODUCTION DEVICES.
        SecVolatileRawUnlockEn: "top_pkg::SecVolatileRawUnlockEn",
        // The following three values get exposed in the life cycle CSRs
        // that are also readable via the TAP.
        SiliconCreatorId: "16'h 4001", // Creator ID for Earlgrey discrete integration
        ProductId: "16'h 0010", // Earlgrey 2
        RevisionId: "8'h 01",   // First tapeout
        IdcodeValue: "jtag_id_pkg::LC_CTRL_JTAG_IDCODE",
        EscNumSeverities: "AlertHandlerEscNumSeverities",
        EscPingCountWidth: "AlertHandlerEscPingCountWidth",
      },
    },
    { name: "alert_handler",
      type: "alert_handler",
      template_type: "alert_handler",
      clock_srcs: {clk_i: "io_div4", clk_edn_i: "main"},
      clock_group: "secure",
      reset_connections: {rst_ni: "lc_io_div4", rst_edn_ni: "lc"},
      base_addr: {
        hart: "0x40150000",
      },
      param_decl: {
        EscNumSeverities: "4",
        EscPingCountWidth: "16"
      },
      attr: "ipgen",
    },
    { name: "spi_host0",
      type: "spi_host",
      clock_srcs: {clk_i: "io"},
      clock_group: "peri",
      reset_connections: {rst_ni: "spi_host0"},
      base_addr: {
        hart: "0x40300000",
      },
      param_decl: {
        NumCS: "3"
      },
    },
    { name: "spi_host1",
      type: "spi_host",
      clock_srcs: {clk_i: "io"},
      clock_group: "spi_host1",
      reset_connections: {rst_ni: "spi_host1"},
      base_addr: {
        hart: "0x40310000",
      },
      param_decl: {
        NumCS: "3"
      },
    },
    { name: "usbdev",
      type: "usbdev",
      clock_srcs: {clk_i: "usb", clk_aon_i: "aon"},
      clock_group: "peri",
      reset_connections: {rst_ni: "usb", rst_aon_ni: "usb_aon"},
      base_addr: {
        hart: "0x40320000",
      },
      param_decl: {
        RcvrWakeTimeUs: "100"
      },
    },
    { name: "pwrmgr",
      type: "pwrmgr",
      template_type: "pwrmgr",
      clock_group: "powerup",
      clock_srcs: {
        clk_i: "io_div4",
        clk_slow_i: "aon",
        clk_lc_i: "io_div4",
        clk_esc_i: {
          clock: "io_div4",
          group: "secure"
        }
      },
      reset_connections: {
        rst_ni: {
          name: "por_io_div4",
          domain: "Aon"
        },
        rst_main_ni: {
          name: "por_aon",
          domain: "Main"
        },
        rst_lc_ni: {
          name: "lc_io_div4",
          domain: "Aon"
        },
        rst_esc_ni: {
          name: "lc_io_div4",
          domain: "Aon"
        },
        rst_slow_ni: {
          name: "por_aon",
          domain: "Aon",
        },
      },
      domain: "Aon",
      base_addr: {
        hart: "0x40400000",
      },
      param_decl: {
        EscNumSeverities: "AlertHandlerEscNumSeverities",
        EscPingCountWidth: "AlertHandlerEscPingCountWidth",
      },
      attr: "ipgen",
    },
    { name: "rstmgr",
      type: "rstmgr",
      template_type: "rstmgr",
      clock_srcs: {
        clk_i: {
          clock: "io_div4",
          group: "powerup"
        },
        clk_por_i: "io_div4", clk_aon_i: "aon", clk_main_i: "main", clk_io_i: "io", clk_usb_i: "usb",
        clk_io_div4_i: "io_div4"
      },
      clock_group: "powerup",
      reset_connections: {
        rst_ni: {
          name: "lc_io_div4",
          domain: "Aon"
        },
        rst_por_ni: {
          name: "por_io_div4",
          domain: "Aon"
        },
      },
      domain: "Aon",
      base_addr: {
        hart: "0x40410000",
      },
      attr: "ipgen",
    },
    { name: "clkmgr",
      type: "clkmgr",
      template_type: "clkmgr",
      clock_srcs: {
        clk_i: "io_div4",
        clk_main_i: {
          group: "ast",
          clock: "main"
        },
        clk_io_i: {
          group: "ast",
          clock: "io"
        },
        clk_usb_i: {
          group: "ast",
          clock: "usb"
        },
        clk_aon_i: {
          group: "ast",
          clock: "aon"
        }
      },
      clock_group: "powerup",
      reset_connections: {rst_ni: "lc_io_div4",
                          rst_aon_ni: "lc_aon",
                          rst_io_ni: "lc_io",
                          rst_io_div4_ni: "lc_io_div4",
                          rst_main_ni: "lc",
                          rst_usb_ni: "lc_usb",
                          rst_root_ni: "por_io_div4",
                          rst_root_io_ni: "por_io",
                          rst_root_io_div4_ni: "por_io_div4",
                          rst_root_main_ni: "por",
                          rst_root_usb_ni: "por_usb",
                         },
      domain: "Aon",
      base_addr: {
        hart: "0x40420000",
      },
      attr: "ipgen",
    },
    { name: "sysrst_ctrl",
      type: "sysrst_ctrl",
      clock_srcs: {clk_i: "io_div4", clk_aon_i: "aon"},
      clock_group: "secure",
      reset_connections: {rst_ni: "lc_io_div4", rst_aon_ni: "lc_aon"},
      domain: "Aon",
      base_addr: {
        hart: "0x40430000",
      }
    },
    { name: "adc_ctrl",
      type: "adc_ctrl",
      clock_srcs: {clk_i: "io_div4", clk_aon_i: "aon"},
      clock_group: "peri",
      reset_connections: {rst_ni: "lc_io_div4", rst_aon_ni: "lc_aon"},
      domain: "Aon",
      base_addr: {
        hart: "0x40440000",
      }
    },
    { name: "pinmux",
      type: "pinmux",
      template_type: "pinmux",
      clock_srcs: {
        primary: {clk_i: "io_div4", clk_aon_i: "aon"},
        secondary: {clk_i: "io_div4"},
      },
      clock_group: {primary: "powerup", secondary: "secure"},
      reset_connections: {
        primary: {
          rst_ni: {
            name: "lc_io_div4",
            domain: "Aon",
          },
          rst_aon_ni: {
            name: "lc_aon",
            domain: "Aon"
          },
          rst_sys_ni: {
            name: "sys_io_div4",
            domain: "Aon",
          },
        },
        secondary: {
          rst_ni: {
            name: "lc_io_div4",
            domain: "Main",
          },
        },
      },
      domain: "Aon",
      domain_secondary: "Main",
      base_addr: {
        hart: "0x40460000",
      },
      attr: "ipgen",
      param_decl: {
        // NOTE THAT THIS IS A FEATURE FOR TEST CHIPS ONLY TO MITIGATE
        // THE RISK OF A BROKEN OTP MACRO. THIS WILL BE DISABLED FOR
        // PRODUCTION DEVICES.
        SecVolatileRawUnlockEn: "top_pkg::SecVolatileRawUnlockEn",
      }
    },
    { name: "aon_timer",
      type: "aon_timer",
      clock_srcs: {clk_i: "io_div4", clk_aon_i: "aon"},
      clock_group: "timers",
      reset_connections: {rst_ni: "lc_io_div4", rst_aon_ni: "lc_aon"},
      domain: "Aon",
      base_addr: {
        hart: "0x40470000",
      },
    },
    { name: "ast",
      type: "ast",
      clock_srcs: {
        primary: {
          clk_ast_tlul_i: {
            clock: "io_div4",
            group: "infra"
          },
          clk_ast_es_i: {
            clock: "main",
            group: "secure"
          },
          clk_ast_rng_i: {
            clock: "main",
            group: "secure"
          },
          clk_ast_usb_i: {
            clock: "usb",
            group: "peri"
          },
          clk_ast_ext_i: "ast_ext",
        },
        secondary: {
          clk_ast_adc_i: {
            clock: "aon",
            group: "peri"
          },
          clk_ast_alert_i: {
            clock: "io_div4",
            group: "secure"
          },
          clk_ast_ext_i: "ast_ext",
        },
      },
      clock_group: {
        // This has no direct effect for AST as each clock already defines its group.
        primary: "secure",
        secondary: "secure"
      },
      reset_connections: {
        primary: {
          rst_ast_tlul_ni: {
            name: "lc_io_div4",
            domain: "Main",
          },
          rst_ast_es_ni: {
            name: "lc",
            domain: "Main",
          },
          rst_ast_rng_ni: {
            name: "lc",
            domain: "Main",
          },
          rst_ast_usb_ni: {
            name: "usb",
            domain: "Main"
          }
        },
        secondary: {
          rst_ast_adc_ni: {
            name: "lc_aon",
            domain: "Aon"
          },
          rst_ast_alert_ni: {
            name: "lc_io_div4",
            domain: "Main",
          },
        },
      },
      domain: "Main",
      domain_secondary: "Aon",
      base_addr: {
        hart: "0x40480000",
      },
      attr: "reggen_top",
    },
    { name: "sensor_ctrl",
      type: "sensor_ctrl",
      clock_srcs: {clk_i: "io_div4", clk_aon_i: "aon"},
      clock_group: "secure",
      reset_connections: {rst_ni: "lc_io_div4", rst_aon_ni: "lc_aon"},
      domain: "Aon",
      base_addr: {
        hart: "0x40490000",
      },
      attr: "reggen_top",
    },
    { name: "sram_ctrl_ret",
      type: "sram_ctrl",
      clock_srcs: {clk_i: "io_div4", clk_otp_i: "io_div4"},
      clock_group: "infra",
      reset_connections: {rst_ni: "lc_io_div4", rst_otp_ni: "lc_io_div4"},
      domain: "Aon",
      param_decl: {
        InstrExec: "0",
        InstSize: "8192",
      }
      base_addrs: {
        regs: {hart: "0x40500000"},
        ram:  {hart: "0x40600000"},
      }
      // Memory regions must be associated with a dedicated
      // TL-UL device interface.
      memory: {
        ram: {
          label:    "ram_ret_aon",
          swaccess:   "rw",
          data_intg_passthru: "true",
          exec:       "True",
          byte_write: "True",
          size:     "0x2000"
        }
      }
    },
    { name: "rram_ctrl",
      type: "rram_ctrl",
      clock_srcs: {clk_i: "main", clk_otp_i: "io_div4"},
      clock_group: "infra",
      reset_connections: {rst_ni: "lc", rst_otp_ni: "lc_io_div4"},
      base_addrs: {
        core: {hart: "0x41010000"},
        host: {hart: "0x30000000"}
      }
      param_decl: {
        WrFifoDepth: "4",
        RdFifoDepth: "16",
      },
      memory: {
        host: {
          label:      "rram",
          swaccess:   "ro",
          data_intg_passthru: "true",
          exec:       "True",
          byte_write: "False",
          size:       "0x200000"
        }
      },
    },
    { name: "rram_macro",
      type: "rram_macro",
      clock_srcs: {clk_i: "main"},
      clock_group: "infra",
      reset_connections: {rst_ni: "lc"},
      base_addrs: {
        prim: {hart: "0x41018000"},
      },
      param_decl: {
        TotalDataPages: "rram_ctrl_pkg::TotalDataPages",
        DataWidth:      "rram_ctrl_pkg::DataWidth",
        WordsPerPage:   "rram_ctrl_pkg::WordsPerPage",
        TotalInfoPages: "rram_ctrl_pkg::TotalInfoPages",
        MaxWrWords:     "rram_ctrl_pkg::MaxWrWords",
      },
    },
    { name: "rv_dm",
      type: "rv_dm",
      clock_srcs: {clk_i: "main", clk_lc_i: "main"},
      clock_group: "infra",
      reset_connections: {rst_ni: "sys", rst_lc_ni: "lc"},
      param_decl: {
        IdcodeValue: "jtag_id_pkg::RV_DM_JTAG_IDCODE",
        CheriotSupport: "1",
      },
      // Note that this module also contains a bus host.
      base_addrs: {
        mem:  {hart: "0x00010000"},
        regs: {hart: "0x41200000"},
      },
      generate_dif: "False"
    },
    { name: "rv_plic",
      type: "rv_plic",
      template_type: "rv_plic",
      clock_srcs: {clk_i: "main"},
      clock_group: "secure",
      reset_connections: {rst_ni: "lc"},
      base_addr: {
        hart: "0x48000000",
      },
      attr: "ipgen",
      targets: ["rv_core_ibex"]
    },
    { name: "aes",
      type: "aes",
      clock_srcs: {clk_i: "main", clk_edn_i: "main"},
      clock_group: "trans",
      reset_connections: {rst_ni: "lc", rst_edn_ni: "lc"},
      param_decl: {
        AESGCMEnable: "0",
        SecMasking: "1",
        SecSBoxImpl: "aes_pkg::SBoxImplDom"
      }
      base_addr: {
        hart: "0x41100000",
      },
    },
    { name: "hmac",
      type: "hmac",
      clock_srcs: {clk_i: "main"},
      clock_group: "trans",
      reset_connections: {rst_ni: "lc"},
      base_addr: {
        hart: "0x41110000",
      },
    },
    { name: "kmac",
      type: "kmac",
      param_decl: {
        EnMasking: "1",
      }
      clock_srcs: {clk_i: "main", clk_edn_i: "main"}
      clock_group: "trans"
      reset_connections: {rst_ni: "lc", rst_edn_ni: "lc"}
      base_addr: {
        hart: "0x41120000",
      }
    },
    { name: "otbn",
      type: "otbn",
      clock_srcs: {
        clk_i: {
          clock: "main",
          group: "trans"
        },
        clk_edn_i: {
          clock: "main",
          group: "secure"
        },
        clk_otp_i: {
          clock: "io_div4",
          group: "secure"
        },
      },
      clock_group: "trans",
      reset_connections: {rst_ni: "lc", rst_edn_ni: "lc", rst_otp_ni: "lc_io_div4"},
      base_addr: {
        hart: "0x41130000",
      },
    },
    { name: "keymgr_dpe",
      type: "keymgr_dpe",
      clock_srcs: {clk_i: "main", clk_edn_i: "main"},
      clock_group: "secure",
      reset_connections: {rst_ni: "lc", rst_edn_ni: "lc"},
      base_addr: {
        hart: "0x41140000",
      },
      param_decl: {
        NumInstHwSlot: "4",
        NumBootStages: "4",
        NumRomDigestInputs: "1",
        KdfEngineSel: "keymgr_dpe_pkg::KdfEngineBoth",
      },
    },
    { name: "csrng",
      type: "csrng",
      clock_srcs: {clk_i: "main"},
      clock_group: "secure",
      reset_connections: {rst_ni: "lc"},
      base_addr: {
        hart: "0x41150000",
      },
    },
    { name: "entropy_src",
      type: "entropy_src",
      clock_srcs: {clk_i: "main"},
      clock_group: "secure",
      reset_connections: {rst_ni: "lc"},
      base_addr: {
        hart: "0x41160000",
      },
    },
    { name: "edn0",
      type: "edn",
      clock_srcs: {clk_i: "main"},
      clock_group: "secure",
      reset_connections: {rst_ni: "lc"},
      base_addr: {
        hart: "0x41170000",
      },
      param_decl: {
        NumEndPoints: "8",
      },
    },
    { name: "edn1",
      type: "edn",
      clock_srcs: {clk_i: "main"},
      clock_group: "secure",
      reset_connections: {rst_ni: "lc"},
      base_addr: {
        hart: "0x41180000",
      },
      param_decl: {
        NumEndPoints: "1",
      },
    },
    { name: "sram_ctrl_main",
      type: "sram_ctrl",
      clock_srcs: {clk_i: "main", clk_otp_i: "io_div4"},
      clock_group: "infra",
      reset_connections: {rst_ni: "lc", rst_otp_ni: "lc_io_div4"},
      param_decl: {
        InstrExec: "1",
        NumPrinceRoundsHalf: "2",
        InstSize: "131072",
      },
      base_addrs: {
        regs: {hart: "0x411C0000"},
        ram:  {hart: "0x10000000"}
      },
      // Memory regions must be associated with a dedicated
      // TL-UL device interface.
      memory: {
        ram: {
          label:      "ram_main",
          swaccess:   "rw",
          data_intg_passthru: "true",
          exec:       "True",
          byte_write: "True",
          size:       "0x20000"
        }
      }
    },
    { name: "sram_ctrl_sec",
      type: "sram_ctrl",
      clock_srcs: {clk_i: "main", clk_otp_i: "io_div4"},
      clock_group: "infra",
      reset_connections: {rst_ni: "lc", rst_otp_ni: "lc_io_div4"},
      param_decl: {
        InstrExec: "1",
        NumPrinceRoundsHalf: "2",
        InstSize: "65536",
      },
      base_addrs: {
        regs: {hart: "0x411D0000"},
        ram:  {hart: "0x10020000"}
      },
      // Memory regions must be associated with a dedicated
      // TL-UL device interface.
      memory: {
        ram: {
          label:      "ram_secondary",
          swaccess:   "rw",
          data_intg_passthru: "true",
          exec:       "True",
          byte_write: "True",
          size:       "0x10000"
        }
      }
    },
    { name: "rom_ctrl",
      type: "rom_ctrl",
      clock_srcs: {clk_i: "main"},
      clock_group: "infra",
      reset_connections: {rst_ni: "lc"},
      // The ROM section is PMP protected. If either base addr or size is changed then
      // the reset values for the PMP migth changes too (ibex_pmp_reset_pkg.sv).
      base_addrs: {
        rom:  {hart: "0x00040000"},
        regs: {hart: "0x411e0000"}
      }
      memory: {
        rom: {
          label:              "rom",
          swaccess:           "ro",
          data_intg_passthru: "true",
          exec:               "True",
          byte_write:         "False",
          size:               "0x30000",
          data_intg_passthru: "True"
        }
      },
      param_decl: {
        SecDisableScrambling: "1'b0"
      }
    },
    { name: "rv_core_ibex",
      type: "rv_core_ibex",
      template_type: "rv_core_ibex",
      attr: "ipgen",
      ipgen_params: {
        num_regions: 2
        cheriot_available: true
      }
      param_decl: {PMPEnable: "1",
                   PMPGranularity: "0",
                   PMPNumRegions: "16",
                   MHPMCounterNum: "2",
                   MHPMCounterWidth: "32",
                   PMPRstCfg: "ibex_pmp_reset_pkg::PmpCfgRst",
                   PMPRstAddr: "ibex_pmp_reset_pkg::PmpAddrRst",
                   PMPRstMsecCfg: "ibex_pmp_reset_pkg::PmpMseccfgRst",
                   CheriotRevBitmapAddrWidth: "$clog2(tl_main_pkg::ADDR_SIZE_CHERIOT_MEM_SYS__REVBM)",
                   CheriotRevBitmapBaseAddr: "tl_main_pkg::ADDR_SPACE_CHERIOT_MEM_SYS__REVBM",
                   CheriotTrvkHeapBaseAddr: "tl_main_pkg::ADDR_SPACE_SRAM_CTRL_MAIN__RAM",
                   RV32E: "0",
                   RV32M: "ibex_pkg::RV32MSingleCycle",
                   RV32B: "ibex_pkg::RV32BFull",
                   RV32ZC: "ibex_pkg::RV32ZcaZcbZcmp",
                   RegFile: "ibex_pkg::RegFileFF",
                   BranchTargetALU: "1",
                   WritebackStage: "1",
                   ICache: "1",
                   ICacheECC: "1",
                   ICacheScramble: "1",
                   BranchPredictor: "0",
                   DbgTriggerEn: "1",
                   DbgHwBreakNum: "4",
                   SecureIbex: "1",
                   DmBaseAddr: "tl_main_pkg::ADDR_SPACE_RV_DM__MEM",
                   DmAddrMask: "tl_main_pkg::ADDR_MASK_RV_DM__MEM",
                   DmHaltAddr: "tl_main_pkg::ADDR_SPACE_RV_DM__MEM + dm::HaltAddress[31:0]",
                   DmExceptionAddr: "tl_main_pkg::ADDR_SPACE_RV_DM__MEM + dm::ExceptionAddress[31:0]",
                   PipeLine: "0",
                   NEscalationSeverities: "AlertHandlerEscNumSeverities",
                   WidthPingCounter: "AlertHandlerEscPingCountWidth",
                  },
      clock_srcs: {
        clk_i: "main",
        clk_edn_i: "main",
        clk_esc_i: {
          clock: "io_div4",
          group: "secure",
        },
        clk_otp_i: {
          clock: "io_div4",
          group: "secure",
        }
      },
      clock_group: "infra",
      reset_connections: {rst_ni: "lc",
                          rst_edn_ni: "lc",
                          rst_esc_ni: "lc_io_div4",
                          rst_otp_ni: "lc_io_div4"},
      base_addr: {
        hart: "0x411F0000",
      },
    },
    { name: "cheriot_mem_sys",
      type: "cheriot_mem_sys",
      clock_srcs: {clk_i: "main"},
      clock_group: "infra",
      reset_connections: {rst_ni: "lc"},
      param_decl: {
        MainSramBaseAddr: "tl_main_pkg::ADDR_SPACE_SRAM_CTRL_MAIN__RAM",
        MainSramTopAddr:  "tl_main_pkg::ADDR_SPACE_SRAM_CTRL_SEC__RAM + tl_main_pkg::ADDR_MASK_SRAM_CTRL_SEC__RAM + 1",
        NvmBaseAddr:      "tl_main_pkg::ADDR_SPACE_RRAM_CTRL__HOST",
        NvmTopAddr:       "tl_main_pkg::ADDR_SPACE_RRAM_CTRL__HOST + tl_main_pkg::ADDR_MASK_RRAM_CTRL__HOST + 1",
        MetaSramBaseAddr: "tl_main_pkg::ADDR_SPACE_CHERIOT_MEM_SYS__REVBM",
      },
      base_addrs: {
        regs:  {hart: "0x411B0000"},
        revbm: {hart: "0x11000000"},
      },
      memory: {
        revbm: {
          label:              "cheriot_revbm",
          swaccess:           "rw",
          data_intg_passthru: "True",
          exec:               false,
          byte_write:         "False",
          size:               "0xc00"
        }
      },
    },
    { name: "sram_ctrl_meta",
      type: "sram_ctrl",
      clock_srcs: {clk_i: "main", clk_otp_i: "io_div4"},
      clock_group: "infra",
      reset_connections: {rst_ni: "lc", rst_otp_ni: "lc_io_div4"},
      param_decl: {
        InstrExec: "0",
        // Set back to the default of 2 once address scrambling supports the
        // 38 KiB meta SRAM depth.
        NumAddrScrRounds: "0",
        NumPrinceRoundsHalf: "2",
        InstSize: "38912",
        // The CHERIoT revocation bitmap and validity tags must read back as zero initially, to
        // avoid very long software initialization processes. Note that this only takes effect
        // once early boot code actually triggers the SRAM controller's hardware initialization
        // via CTRL.INIT; the ROM does not yet do so for this instance.
        SecZeroInit: "1",
      },
      base_addrs: {
        regs: {hart: "0x411A0000"},
        // Aliases cheriot_mem_sys.revbm on purpose: the revocation bitmap sits at the base of the
        // meta SRAM, so the software-visible window and this RAM interface describe the same
        // memory. Only cheriot_mem_sys.revbm is reachable from the main crossbar; this RAM
        // interface is driven by the CHERIoT memory subsystem alone.
        ram:  {hart: "0x11000000"}
      },
      // Memory regions must be associated with a dedicated
      // TL-UL device interface.
      memory: {
        ram: {
          label:      "ram_cheriot_meta",
          swaccess:   "rw",
          data_intg_passthru: "true",
          exec:       false,
          byte_write: "False",
          size:       "0x9800"
        }
      }
    },
  ],

  // The port data structure is not something that should be used liberally.
  // It is used specifically to assign special attributes to specific ports.
  // For example, this allows us to designate a port as part of inter-module
  // connections.
  port: [],

  // Inter-module Connection.
  // format:
  //    requester: [ resp1, resp2, ... ],
  //
  //  the field and value should be module_inst.port_name
  //  e.g csrng.csrng_cmd: ['edn0.csrng_cmd', 'edn1.csrng_cmd']
  inter_module: {
    'connect': {
      // AST connections
      'ast.obs_ctrl'            : ['rram_macro.obs_ctrl'],
      'ast.adc'                 : ['adc_ctrl.adc'],
      // Requires a manual connection of sense signals as clks/rsts are also defined as external.
      'ast.sns_clks'            : ['clkmgr.clocks'],
      'ast.sns_rsts'            : ['rstmgr.resets'],
      'ast.clk_src_sys_jen'     : ['clkmgr.jitter_en'],
      'ast.rng_b'               : ['entropy_src.entropy_src_rng_bits'],
      'entropy_src.entropy_src_rng_enable' : ['ast.rng_en'],
      'entropy_src.rng_fips'    : ['ast.rng_fips'],
      'ast.rng_val'             : ['entropy_src.entropy_src_rng_valid'],
      'ast.init_done'           : ['clkmgr.calib_rdy',
                                   'sensor_ctrl.ast_init_done'],
      'ast.ast2padmux'          : ['sensor_ctrl.ast2pinmux'],
      'ast.io_pwr_st'           : ['sensor_ctrl.ast_status'],
      'usbdev.usb_ref_pulse'    : ['ast.usb_ref_pulse'],
      'usbdev.usb_ref_val'      : ['ast.usb_ref_val'],
      'pinmux.dft_strap_test'   : ['ast.dft_strap_test'],
      'clkmgr.all_clk_byp_req'  : ['ast.all_clk_byp_req'],
      'clkmgr.all_clk_byp_ack'  : ['ast.all_clk_byp_ack'],
      'clkmgr.io_clk_byp_req'   : ['ast.io_clk_byp_req'],
      'clkmgr.io_clk_byp_ack'   : ['ast.io_clk_byp_ack'],
      'clkmgr.hi_speed_sel'     : ['ast.ext_freq_is_96m'],
      'clkmgr.div_step_down_req': ['ast.clk_src_io_48m'],
      'sensor_ctrl.ast_alert'   : ['ast.alert'],

      'alert_handler.crashdump' : ['rstmgr.alert_dump'],
      'alert_handler.esc_rx'    : ['rv_core_ibex.esc_rx',
                                   'lc_ctrl.esc_scrap_state0_rx',
                                   'lc_ctrl.esc_scrap_state1_rx',
                                   'pwrmgr.esc_rst_rx'],
      'alert_handler.esc_tx'    : ['rv_core_ibex.esc_tx',
                                   'lc_ctrl.esc_scrap_state0_tx',
                                   'lc_ctrl.esc_scrap_state1_tx',
                                   'pwrmgr.esc_rst_tx'],
      'aon_timer.nmi_wdog_timer_bark' : ['rv_core_ibex.nmi_wdog'],
      'csrng.csrng_cmd'         : ['edn0.csrng_cmd', 'edn1.csrng_cmd'],
      'csrng.entropy_src_hw_if' : ['entropy_src.entropy_src_hw_if'],
      'rram_ctrl.otp_key'       : ['otp_ctrl.nvm_otp_key'],
      'lc_ctrl.lc_nvm_rma_seed' : ['rram_ctrl.rma_seed'],
      'otp_ctrl.sram_otp_key'   : ['sram_ctrl_main.sram_otp_key',
                                   'sram_ctrl_sec.sram_otp_key',
                                   'sram_ctrl_ret.sram_otp_key',
                                   'sram_ctrl_meta.sram_otp_key',
                                   'rv_core_ibex.icache_otp_key'],
      'pwrmgr.pwr_ast'          : ['ast.pwrmgr'],
      'pwrmgr.pwr_nvm'          : ['rram_ctrl.pwrmgr'],
      'pwrmgr.pwr_rst'          : ['rstmgr.pwr'],
      'pwrmgr.pwr_clk'          : ['clkmgr.pwr'],
      'pwrmgr.pwr_otp'          : ['otp_ctrl.pwr_otp'],
      'pwrmgr.pwr_lc'           : ['lc_ctrl.pwr_lc'],
      'pwrmgr.strap'            : ['pinmux.strap_en'],
      'pwrmgr.low_power'        : ['pinmux.sleep_en',
                                   'aon_timer.sleep_mode'],
      'pwrmgr.fetch_en'         : ['rv_core_ibex.pwrmgr_cpu_en'],
      'rom_ctrl.pwrmgr_data'    : ['pwrmgr.rom_ctrl'],
      'rom_ctrl.keymgr_data'    : ['keymgr_dpe.rom_digest'],
      'alert_handler.crashdump' : ['rstmgr.alert_dump'],

      // LC RMA req/ack interface: LC --> RRAM  -> LC
      //                              |-> OTBN  -> LC
      'lc_ctrl.lc_nvm_rma_req' : ['otbn.lc_rma_req', 'rram_ctrl.rma_req'],
      'lc_ctrl.lc_nvm_rma_ack' : ['rram_ctrl.rma_ack', 'otbn.lc_rma_ack'],

      // usbdev connection to pinmux
      'usbdev.usb_dp_pullup'             : ['pinmux.usbdev_dppullup_en'],
      'usbdev.usb_dn_pullup'             : ['pinmux.usbdev_dnpullup_en'],
      'usbdev.usb_aon_suspend_req'       : ['pinmux.usbdev_suspend_req'],
      'usbdev.usb_aon_wake_ack'          : ['pinmux.usbdev_wake_ack'],
      'usbdev.usb_aon_bus_not_idle'      : ['pinmux.usbdev_bus_not_idle'],
      'usbdev.usb_aon_bus_reset'         : ['pinmux.usbdev_bus_reset'],
      'usbdev.usb_aon_sense_lost'        : ['pinmux.usbdev_sense_lost'],
      'pinmux.usbdev_wake_detect_active' : ['usbdev.usb_aon_wake_detect_active'],

      // Edn connections
      'edn0.edn'              : ['keymgr_dpe.edn', 'otp_ctrl.edn', 'ast.edn', 'kmac.entropy',
                                 'alert_handler.edn', 'aes.edn', 'otbn.edn_urnd',
                                 'rv_core_ibex.edn'],
      'edn1.edn'              : ['otbn.edn_rnd'],

      // OTBN OTP scramble key
      'otp_ctrl.otbn_otp_key' : ['otbn.otbn_otp_key'],

      // KeyMgr DPE Sideload & KDF function
      'otp_ctrl.keymgr_creator_root_key'  : ['keymgr_dpe.creator_root_key'],
      'otp_ctrl.keymgr_field_entropy'     : ['keymgr_dpe.field_entropy'],
      // The creator / owner seed is provided by the rram_ctrl.
      'rram_ctrl.keymgr_creator_seed'     : ['keymgr_dpe.creator_seed'],
      'rram_ctrl.keymgr_owner_seed'       : ['keymgr_dpe.owner_seed'],
      'keymgr_dpe.aes_key'                : ['aes.keymgr_key'],
      'keymgr_dpe.kmac_key'               : ['kmac.keymgr_key'],
      'keymgr_dpe.hmac_key'               : ['hmac.keymgr_key'],
      'keymgr_dpe.otbn_key'               : ['otbn.keymgr_key'],

      // KMAC Application Interface
      'kmac.app'                : ['keymgr_dpe.kmac_app', // Keymgr needs to be at index 0
                                   'lc_ctrl.kmac_data',   // LC needs to be at index 1
                                   'rom_ctrl.kmac_data',  // ROM needs to be at index 2
                                   'otbn.kmac_app'],      // OTBN needs to be at index 3
      'kmac.en_masking'         : ['keymgr_dpe.kmac_en_masking'],

      // OTBN Application Interface
      'otbn.keymgr_app'           : ['keymgr_dpe.otbn_app'],
      'otbn.keymgr_sensitive_key' : ['keymgr_dpe.sensitive_key'],

      // The idle connection is automatically connected through topgen.
      // The user does not need to explicitly declare anything other than
      // an empty list.
      'clkmgr.idle'             : [],

      // Pinmux JTAG signals
      'pinmux.lc_jtag' : ['lc_ctrl.jtag'],
      'pinmux.rv_jtag' : ['rv_dm.jtag'],
      'pinmux.rram_jtag' : ['rram_macro.jtag'],
      // Latched HW debug life cycle signal that is forwarded to RV_DM
      'pinmux.pinmux_hw_debug_en' : ['rv_dm.pinmux_hw_debug_en'],

      // OTP LC interface
      'otp_ctrl.otp_lc_data'       : ['lc_ctrl.otp_lc_data'],
      'lc_ctrl.lc_otp_program'     : ['otp_ctrl.lc_otp_program'],

      // Diversification constant coming from life cycle
      'lc_ctrl.lc_keymgr_div'  : ['keymgr_dpe.lc_keymgr_div'],

      // Strap enable override signal, only used when SecVolatileRawUnlockEn = 1.
      'lc_ctrl.strap_en_override'  : ['pinmux.strap_en_override'],

      // LC function control signal broadcast
      'lc_ctrl.lc_dft_en'          : ['pinmux.lc_dft_en',
                                      'ast.lc_dft_en',
                                      'pwrmgr.lc_dft_en',
                                      'rv_dm.lc_dft_en'
                                     ],
      'lc_ctrl.lc_nvm_debug_en'    : ['rram_macro.lc_nvm_debug_en',
                                      'pinmux.lc_nvm_debug_en'],
      'lc_ctrl.lc_hw_debug_clr'    : ['pinmux.lc_hw_debug_clr',
                                      'rv_dm.lc_hw_debug_clr'],
      'lc_ctrl.lc_init_done'       : ['rv_dm.lc_init_done'],
      'lc_ctrl.lc_hw_debug_en'     : ['sram_ctrl_main.lc_hw_debug_en',
                                      'sram_ctrl_sec.lc_hw_debug_en',
                                      'sram_ctrl_meta.lc_hw_debug_en',
                                      'pinmux.lc_hw_debug_en',
                                      'csrng.lc_hw_debug_en',
                                      'rv_dm.lc_hw_debug_en',
                                      'clkmgr.lc_hw_debug_en',
                                      'pwrmgr.lc_hw_debug_en',],
      'lc_ctrl.lc_cpu_en'          : ['rv_core_ibex.lc_cpu_en'],
      'lc_ctrl.lc_keymgr_en'       : ['keymgr_dpe.lc_keymgr_en'],
      'lc_ctrl.lc_escalate_en'     : ['aes.lc_escalate_en',
                                      'kmac.lc_escalate_en',
                                      'otbn.lc_escalate_en',
                                      'otp_ctrl.lc_escalate_en',
                                      'sram_ctrl_main.lc_escalate_en',
                                      'sram_ctrl_sec.lc_escalate_en',
                                      'sram_ctrl_ret.lc_escalate_en',
                                      'sram_ctrl_meta.lc_escalate_en',
                                      'aon_timer.lc_escalate_en',
                                      'rram_ctrl.lc_escalate_en',
                                      'pinmux.lc_escalate_en'],

      'lc_ctrl.lc_check_byp_en'    : ['otp_ctrl.lc_check_byp_en',
                                      'pinmux.lc_check_byp_en'],
      'lc_ctrl.lc_clk_byp_req'     : ['clkmgr.lc_clk_byp_req'],
      'lc_ctrl.lc_clk_byp_ack'     : ['clkmgr.lc_clk_byp_ack'],

      // LC access control signal broadcast
      'lc_ctrl.lc_creator_seed_sw_rw_en'   : ['otp_ctrl.lc_creator_seed_sw_rw_en',
                                              'rram_ctrl.lc_creator_seed_sw_rw_en'],
      'lc_ctrl.lc_owner_seed_sw_rw_en'     : ['rram_ctrl.lc_owner_seed_sw_rw_en'],
      'lc_ctrl.lc_iso_part_sw_rd_en'       : ['rram_ctrl.lc_iso_part_sw_rd_en'],
      'lc_ctrl.lc_iso_part_sw_wr_en'       : ['rram_ctrl.lc_iso_part_sw_wr_en'],
      'lc_ctrl.lc_seed_hw_rd_en'           : ['otp_ctrl.lc_seed_hw_rd_en',
                                              'rram_ctrl.lc_seed_hw_rd_en'],
      'lc_ctrl.lc_rma_state'               : ['otp_ctrl.lc_rma_state'],

      // OTP_CTRL RRAM_CTRL connections
      'otp_ctrl.otp_macro'                 : ['rram_ctrl.otp_macro'],

      // rv_plic connections
      'rv_plic.msip' : ['rv_core_ibex.irq_software'],
      'rv_plic.irq'  : ['rv_core_ibex.irq_external'],

      // rv_dm connections
      'rv_dm.debug_req': ['rv_core_ibex.debug_req'],

      // rv_timer connections


      // rv core ibex connections
      'rv_core_ibex.crash_dump'    : ['rstmgr.cpu_dump'],
      'rv_core_ibex.pwrmgr'        : ['pwrmgr.pwr_cpu'],
      'rv_core_ibex.cored_tl_h'    : ['cheriot_mem_sys.cored_tl_d'],
      'rv_core_ibex.corerevbm_tl'  : ['cheriot_mem_sys.corerevbm_tl'],
      'rv_core_ibex.cored_tag_h2d' : ['cheriot_mem_sys.cored_tag_h2d'],

      // spi passthrough connection
      'spi_device.passthrough'     : ['spi_host0.passthrough'],

      // Debug module reset request to power manager
      'rv_dm.ndmreset_req' : ['pwrmgr.ndmreset_req'],

      // Reset manager software reset request to pwrmgr
      'rstmgr.sw_rst_req' : ['pwrmgr.sw_rst_req'],
      // Reset manager power-on reset request from AST
      'rstmgr.por_n' : ['ast.rstmgr_por_n'],

      // connection between rram_macro and rram_ctrl
      'rram_ctrl.rram_macro' : ['rram_macro.rram_macro'],

      // CHERIoT connections
      'cheriot_mem_sys.meta_sram_tl'  : ['sram_ctrl_meta.ram_tl'],
      'cheriot_mem_sys.cored_tag_d2h' : ['rv_core_ibex.cored_tag_d2h'],
      'rv_core_ibex.cheriot_ena'      : ['cheriot_mem_sys.cheriot_ena', 'rv_dm.cheriot_ena'],
    },

    // top is to connect to top net/struct.
    // It defines the signal in the top and connect from the module,
    // use of the signal is up to top template
    'top': [
        // top level net for clocks
        'clkmgr.clocks',

        // Net for raw aon clock from AST
        'ast.clk_src_aon',

        // Net for bypass clock for FPGA
        'ast.clk_osc_byp.primary',

        // Memory configurations for main PD
        'ast.mem_cfg.primary',
        'otbn.ram_cfg_imem',
        'otbn.ram_cfg_dmem',
        'i2c0.ram_cfg',
        'i2c1.ram_cfg',
        'i2c2.ram_cfg',
        'i3c0.ram_cfg',
        'i3c0.dat_cfg',
        'i3c0.dct_cfg',
        'i3c1.ram_cfg',
        'i3c1.dat_cfg',
        'i3c1.dct_cfg',
        'usbdev.ram_cfg',
        'rv_core_ibex.ram_cfg_icache_tag',
        'rv_core_ibex.ram_cfg_icache_data',
        'sram_ctrl_main.ram_cfg',
        'sram_ctrl_sec.ram_cfg',
        'sram_ctrl_meta.ram_cfg',
        'spi_device.ram_cfg_sys2spi',
        'spi_device.ram_cfg_spi2sys',
        'rom_ctrl.rom_cfg',

        // Memory configurations for AON PD
        'ast.mem_cfg.secondary',
        'sram_ctrl_ret.ram_cfg',

        // top level clock gating indications for alert subsystem
        'clkmgr.cg_en',

        // top level net for reset
        'rstmgr.resets',

        // top level reset asserted indications for alert subsystem
        'rstmgr.rst_en',

        // dedicated timer interrupt
        'rv_core_ibex.irq_timer',

        // hardwired connections
        'rv_core_ibex.hart_id', 'rv_core_ibex.boot_addr',

        // Pinmux JTAG signals for the tool-inserted DFT TAP
        'pinmux.dft_jtag',

        // OTP HW_CFG* Broadcast signals.
        // TODO(#6713): The actual struct breakout and mapping currently needs to
        // be performed by hand in the toplevel template.
        'otp_ctrl.otp_broadcast',
        'lc_ctrl.otp_device_id',
        'lc_ctrl.otp_manuf_state',
        'keymgr_dpe.device_id',
        'sram_ctrl_main.otp_en_sram_ifetch',
        'sram_ctrl_sec.otp_en_sram_ifetch',
        'rv_dm.otp_dis_rv_dm_late_debug',
    ],

    // ext is to create port in the top.
    'external': {
        'ast.por_n'                          : 'manual_in_por_n',
        'ast.pora_n'                         : 'manual_in_pora_n',
        'ast.dft_scan_md'                    : 'scanmode',
        'ast.scan_shift_en'                  : 'scan_en',
        'ast.scan_reset_n'                   : 'scan_rst_n',
        'ast.usb_io_pu_cal'                  : 'usb_io_pu_cal',
        'ast.padmux2ast'                     : 'padmux2ast',
        'ast.vx_supp'                        : '',
        'ast.obs'                            : '',
        'ast.adc_a0_a'                       : '',
        'ast.adc_a1_a'                       : '',
        'ast.ast2pad_t0_a'                   : 'ast2pad_t0_a',
        'ast.ast2pad_t1_a'                   : 'ast2pad_t1_a',
        'ast.clk_osc_byp.primary'            : 'clks_osc_byp',
        'ast.ast_pwst_h'                     : 'ast_pwst_h',
        'pinmux.dft_hold_tap_sel'            : 'dft_hold_tap_sel',
        'pinmux.usb_dppullup_en'             : 'usb_dp_pullup_en',
        'pinmux.usb_dnpullup_en'             : 'usb_dn_pullup_en',
        'rram_macro.rram_test_analog'        : 'rram_test_analog',
        'sensor_ctrl.manual_pad_attr'        : 'sensor_ctrl_manual_pad_attr',
        'usbdev.usb_rx_d'                    : '',
        'usbdev.usb_tx_d'                    : '',
        'usbdev.usb_tx_se0'                  : '',
        'usbdev.usb_tx_use_d_se0'            : '',
        'usbdev.usb_rx_enable'               : '',
    },
  },

  // Crossbars: having a top level crossbar
  // This version assumes all crossbars are instantiated at the top.
  // Assume xbar.hjson is located in the same directory of top.hjson
  xbar: [
    { name: "main",
      clock_srcs: {clk_main_i: "main",
                   clk_fixed_i: "io_div4",
                   clk_usb_i: "usb",
                   clk_io_i: "io"},
      clock_group: "infra",
      reset: "lc",
      reset_connections: {rst_main_ni: "lc",
                          rst_fixed_ni: "lc_io_div4",
                          rst_usb_ni: "lc_usb",
                          rst_io_ni: "lc_io"}
    },
    { name: "peri",
      clock_srcs: {clk_peri_i: "io_div4", },
      clock_group: "infra",
      reset: "lc_io_div4",
      reset_connections: {rst_peri_ni: "lc_io_div4"},
    }
  ],

  // ===== PINMUX & PINOUT ======================================================

  pinout: {
    // IO power bank declaration.
    // This list defines the IO bank power domains on the ASIC.
    // Each individual pad must be in one of the declared power domains.
    banks: ['VCC', 'AVCC', 'VIOA', 'VIOB'],
    // Pad declaration.
    // Each entry must have the following four keys:
    //
    // - name: Name of the pad (this will be exposed at the chiplevel).
    //
    // - type: Pad type (this maps to the pad types defined in prim_pad_wrapper_pkg.sv)
    //
    // - bank: Specifies in which of the IO power banks this pad lives.
    //
    // - connection: Can have either of the following values:
    //
    //               1) 'direct': This is a dedicated IO Pad that is directly connected to a peripheral.
    //
    //               2) 'manual': This is a dedicated IO signal that is not directly connected to a
    //                            peripheral. It needs to be manually wired up in the template.
    //
    //               3) 'muxed': This is a muxed IO pad that will be connected to the pinmux.
    //
    // Optionally, each pad can also have the following keys:
    //
    // - desc: A field for further description.
    //
    // - port_type: A field to override the default 'inout wire' type (this is currently only used
    //              for simulating ADC connections where the ports have to be switched to a real
    //              type when the ANALOGSIM macro is defined).
    //
    // Muxed and direct pads may also have:
    //
    // - attrs: This field allows to define the reset values of the MIO/DIO_PAD_ATTR CSR of direct
    //          or muxed pads. It is a dict mapping CSR field names to integer reset values. An
    //          example is: `attrs: {virtual_od_en: 1, drive_strength: 3}`
    //
    //          Fields not specified keep the default reset value of the pinmux. Whether a pad
    //          supports an attribute depends on its type and technology (WARL).
    pads: [
      // Special manually connected pads
      { name: 'POR_N'           , type: 'InputStd',     bank: 'VCC' , connection: 'manual', desc: 'System reset based on VCC'},
      { name: 'PORA_N'          , type: 'InputStd',     bank: 'VIOA', connection: 'manual', desc: 'System reset based on VIOA'},
      { name: 'USB_P'           , type: 'DualBidirTol', bank: 'VCC' , connection: 'manual', desc: 'USB P signal'},
      { name: 'USB_N'           , type: 'DualBidirTol', bank: 'VCC' , connection: 'manual', desc: 'USB N signal'},
      { name: 'CC1'             , type: 'BidirTol',     bank: 'AVCC', connection: 'manual', desc: 'ADC input 1', port_type: '`INOUT_AI'},
      { name: 'CC2'             , type: 'BidirTol',     bank: 'AVCC', connection: 'manual', desc: 'ADC input 2', port_type: '`INOUT_AI'},
      { name: 'RRAM_ANALOG'     , type: 'AnalogIn0',    bank: 'VCC' , connection: 'manual', desc: 'RRAM analog test signal'},
      // Dedicated IOs
      { name: 'SPI_HOST_D0'     , type: 'BidirStr', bank: 'VIOA', connection: 'muxed', desc: 'SPI host data'},
      { name: 'SPI_HOST_D1'     , type: 'BidirStr', bank: 'VIOA', connection: 'muxed', desc: 'SPI host data'},
      { name: 'SPI_HOST_D2'     , type: 'BidirStr', bank: 'VIOA', connection: 'muxed', desc: 'SPI host data'},
      { name: 'SPI_HOST_D3'     , type: 'BidirStr', bank: 'VIOA', connection: 'muxed', desc: 'SPI host data'},
      { name: 'SPI_HOST_CLK'    , type: 'BidirStr', bank: 'VIOA', connection: 'muxed', desc: 'SPI host clock'},
      { name: 'SPI_HOST_CS_L'   , type: 'BidirStr', bank: 'VIOA', connection: 'muxed', desc: 'SPI host chip select'},
      { name: 'SPI_DEV_D0'      , type: 'BidirStr', bank: 'VIOA', connection: 'muxed', desc: 'SPI device data'},
      { name: 'SPI_DEV_D1'      , type: 'BidirStr', bank: 'VIOA', connection: 'muxed', desc: 'SPI device data'},
      { name: 'SPI_DEV_D2'      , type: 'BidirStr', bank: 'VIOA', connection: 'muxed', desc: 'SPI device data'},
      { name: 'SPI_DEV_D3'      , type: 'BidirStr', bank: 'VIOA', connection: 'muxed', desc: 'SPI device data'},
      { name: 'SPI_DEV_CLK'     , type: 'InputStd', bank: 'VIOA', connection: 'muxed', desc: 'SPI device clock'},
      { name: 'SPI_DEV_CS_L'    , type: 'InputStd', bank: 'VIOA', connection: 'muxed', desc: 'SPI device chip select'},
      // IOA
      { name: 'IOA0'            , type: 'BidirStd', bank: 'VIOA', connection: 'muxed' , desc: 'Muxed IO pad'},
      { name: 'IOA1'            , type: 'BidirStd', bank: 'VIOA', connection: 'muxed' , desc: 'Muxed IO pad'},
      { name: 'IOA2'            , type: 'BidirStd', bank: 'VIOA', connection: 'muxed' , desc: 'Muxed IO pad', port_type: '`INOUT_AO'},
      { name: 'IOA3'            , type: 'BidirStd', bank: 'VIOA', connection: 'muxed' , desc: 'Muxed IO pad', port_type: '`INOUT_AO'},
      { name: 'IOA4'            , type: 'BidirStd', bank: 'VIOA', connection: 'muxed' , desc: 'Muxed IO pad'},
      { name: 'IOA5'            , type: 'BidirStd', bank: 'VIOA', connection: 'muxed' , desc: 'Muxed IO pad'},
      { name: 'IOA6'            , type: 'BidirStd', bank: 'VIOA', connection: 'muxed' , desc: 'Muxed IO pad'},
      { name: 'IOA7'            , type: 'BidirStr', bank: 'VIOA', connection: 'muxed' , desc: 'Muxed IO pad'},
      { name: 'IOA8'            , type: 'BidirStr', bank: 'VIOA', connection: 'muxed' , desc: 'Muxed IO pad'},
      // IOB
      { name: 'IOB0'            , type: 'BidirStr', bank: 'VIOB', connection: 'muxed' , desc: 'Muxed IO pad'},
      { name: 'IOB1'            , type: 'BidirStr', bank: 'VIOB', connection: 'muxed' , desc: 'Muxed IO pad'},
      { name: 'IOB2'            , type: 'BidirStr', bank: 'VIOB', connection: 'muxed' , desc: 'Muxed IO pad'},
      { name: 'IOB3'            , type: 'BidirStr', bank: 'VIOB', connection: 'muxed' , desc: 'Muxed IO pad'},
      { name: 'IOB4'            , type: 'BidirStr', bank: 'VIOB', connection: 'muxed' , desc: 'Muxed IO pad'},
      { name: 'IOB5'            , type: 'BidirStr', bank: 'VIOB', connection: 'muxed' , desc: 'Muxed IO pad'},
      { name: 'IOB6'            , type: 'BidirStr', bank: 'VIOB', connection: 'muxed' , desc: 'Muxed IO pad'},
      { name: 'IOB7'            , type: 'BidirStd', bank: 'VIOB', connection: 'muxed' , desc: 'Muxed IO pad'},
      { name: 'IOB8'            , type: 'BidirStd', bank: 'VIOB', connection: 'muxed' , desc: 'Muxed IO pad'},
      { name: 'IOB9'            , type: 'BidirStr', bank: 'VIOB', connection: 'muxed' , desc: 'Muxed IO pad'},
      { name: 'IOB10'           , type: 'BidirStr', bank: 'VIOB', connection: 'muxed' , desc: 'Muxed IO pad'},
      { name: 'IOB11'           , type: 'BidirStr', bank: 'VIOB', connection: 'muxed' , desc: 'Muxed IO pad'},
      { name: 'IOB12'           , type: 'BidirStr', bank: 'VIOB', connection: 'muxed' , desc: 'Muxed IO pad'},
      // IOC
      { name: 'IOC0'            , type: 'BidirStd', bank: 'VCC' , connection: 'muxed' , desc: 'Muxed IO pad'},
      { name: 'IOC1'            , type: 'BidirStd', bank: 'VCC' , connection: 'muxed' , desc: 'Muxed IO pad'},
      { name: 'IOC2'            , type: 'BidirStd', bank: 'VCC' , connection: 'muxed' , desc: 'Muxed IO pad'},
      { name: 'IOC3'            , type: 'BidirStd', bank: 'VCC' , connection: 'muxed' , desc: 'Muxed IO pad'},
      { name: 'IOC4'            , type: 'BidirStd', bank: 'VCC' , connection: 'muxed' , desc: 'Muxed IO pad'},
      { name: 'IOC5'            , type: 'BidirStd', bank: 'VCC' , connection: 'muxed' , desc: 'Muxed IO pad'},
      { name: 'IOC6'            , type: 'BidirStd', bank: 'VCC' , connection: 'muxed' , desc: 'Muxed IO pad'},
      { name: 'IOC7'            , type: 'BidirStd', bank: 'VCC' , connection: 'muxed' , desc: 'Muxed IO pad'},
      // Enable pull-down to ensure TAP strap 0 gets sampled as 0 unless driven to 1 from an external source
      // (and specifically that it gets sampled as 0 when left floating / not connected).
      { name: 'IOC8'            , type: 'BidirStd', bank: 'VCC' , connection: 'muxed' , desc: 'Muxed IO pad', attrs: {pull_en: 1, pull_select: 0}},
      { name: 'IOC9'            , type: 'BidirStd', bank: 'VCC' , connection: 'muxed' , desc: 'Muxed IO pad'},
      { name: 'IOC10'           , type: 'BidirStd', bank: 'VCC' , connection: 'muxed' , desc: 'Muxed IO pad'},
      { name: 'IOC11'           , type: 'BidirStd', bank: 'VCC' , connection: 'muxed' , desc: 'Muxed IO pad'},
      { name: 'IOC12'           , type: 'BidirStd', bank: 'VCC' , connection: 'muxed' , desc: 'Muxed IO pad'},
      // IOR
      { name: 'IOR0'            , type: 'BidirStd', bank: 'VCC' , connection: 'muxed' , desc: 'Muxed IO pad'},
      { name: 'IOR1'            , type: 'BidirStd', bank: 'VCC' , connection: 'muxed' , desc: 'Muxed IO pad'},
      { name: 'IOR2'            , type: 'BidirStd', bank: 'VCC' , connection: 'muxed' , desc: 'Muxed IO pad'},
      { name: 'IOR3'            , type: 'BidirStd', bank: 'VCC' , connection: 'muxed' , desc: 'Muxed IO pad'},
      { name: 'IOR4'            , type: 'BidirStd', bank: 'VCC' , connection: 'muxed' , desc: 'Muxed IO pad'},
      { name: 'IOR5'            , type: 'BidirStd', bank: 'VCC' , connection: 'muxed' , desc: 'Muxed IO pad'},
      { name: 'IOR6'            , type: 'BidirStd', bank: 'VCC' , connection: 'muxed' , desc: 'Muxed IO pad'},
      { name: 'IOR7'            , type: 'BidirStd', bank: 'VCC' , connection: 'muxed' , desc: 'Muxed IO pad'},
      { name: 'IOR8'            , type: 'BidirStd', bank: 'VCC' , connection: 'muxed' , desc: 'Muxed IO pad', attrs: {virtual_od_en: 1}},
      { name: 'IOR9'            , type: 'BidirStd', bank: 'VCC' , connection: 'muxed' , desc: 'Muxed IO pad', attrs: {virtual_od_en: 1}},
      { name: 'IOR10'           , type: 'BidirStd', bank: 'VCC' , connection: 'muxed' , desc: 'Muxed IO pad'},
      { name: 'IOR11'           , type: 'BidirStd', bank: 'VCC' , connection: 'muxed' , desc: 'Muxed IO pad'},
      { name: 'IOR12'           , type: 'BidirStd', bank: 'VCC' , connection: 'muxed' , desc: 'Muxed IO pad'},
      { name: 'IOR13'           , type: 'BidirStd', bank: 'VCC' , connection: 'muxed' , desc: 'Muxed IO pad'},
    ]
  },

  pinmux: {
    // Signal to pinmux/pad mapping.
    // Each entry in the list below must have the following three mandatory keys:
    //
    // - instance: This is the comportable IO instance name where the IO signal comes from.
    //
    // - connection: This key is similar to the connection key in the pinout/pad configuration and
    //               can have either of the following values:
    //
    //               1) 'direct': This is a dedicated IO signal that is directly connected to a pad.
    //                            Such an IO signal must also specify the 'port' key and exactly
    //                            one pad in 'pads' (see further below).
    //
    //               2) 'manual': This is a dedicated IO signal that is not directly connected to a pad.
    //                            It needs to be manually wired up in the template.
    //                            Such an IO signal may have a 'port' key and must have an empty
    //                            'pads'.
    //
    //               3) 'muxed': This is a muxed IO signal that will be connected to the pinmux.
    //                           Such an IO signal may have a 'port' key.
    //
    // - pads: Required list of pad names. The content depends on the connection type:
    //         direct: Exactly one entry, the direct pad this signal is connected to.
    //         manual: No meaning. Must be an empty list.
    //         muxed:  Restricts the muxing to the listed muxed pads. An empty list means that the
    //                 signal can be muxed to all muxed pads and all pads can be muxed to this
    //                 signal. The muxing constraint also depends on the direction of the signal:
    //                 - Input:  defines the pads this signal can select (INSEL).
    //                 - Output: defines the pads that can select this signal (OUTSEL).
    //                 - Inout:  defines both directions at once.
    //
    //                 If 'port' is empty, the list applies to all ports of the instance.
    //
    // Depending on the connection type specified, each entry may have the following optional keys:
    //
    // - port: Name of the available IO signal of the instance.
    //         This is required for 'direct' connections, but optional for the others.
    //         Individual signals of a bus IO signal must be indexed with square brackets, e.g. mybus[1].
    //         Not specifying this key or setting it to an empty string acts as a wild card
    //         and includes all available IOs of this instance.
    //
    // - default: Defines the muxing at reset of a muxed signal, i.e., the reset values of the INSEL
    //            and OUTSEL registers. Only muxed connections may have this key. The possible
    //            values depend on the signal direction:
    //
    //            If input:  Defines the INSEL reset value for this signal. Possible defaults are:
    //                       - a pad name (string): Signal is connected to this pad at reset.
    //                       - 0 or 1 (int):        Signal is driven to '0 or '1 at reset.
    //
    //                       If default is not specified, the signal is driven to '0.
    //
    //            If output: The value must be a pad name. If given, this pad is then driven by
    //                       this signal after reset (defines the OUTSEL reset value for this pad).
    //                       Each pad may only be referenced once in the complete 'signals' list as
    //                       a default pad.
    //
    //                       If a pad is never specified as a default, the pad is set to high-Z at
    //                       reset.
    //
    //            If inout:  Defines the INSEL and OUTSEL reset values for this signal and pad.
    //                       Possible defaults are:
    //                       - a pad name (string): Signal is connected to this pad at reset and the
    //                                              pad's default output is this signal.
    //                       - 0 or 1 (int):        Signal is driven to '0 or '1 at reset. Imposes
    //                                              no default source for any pad.
    //
    //                       If this default is not specified, the signal is driven to '0 and no pad
    //                       default is derived.
    //
    // - follower: Only allowed for muxed 1-bit input or bidir signals. A string naming another
    //             comportable input which is controlled by the same INSEL CSR, decoded as
    //             'instance.port'. The follower must always be a 1-bit input and must not have
    //             its own signal entry. It gets no INSEL CSR of its own.
    //
    //             This allows controlling with one INSEL CSR the muxing of signals which go to
    //             different IPs or partitions of an IP. Examples are the reset detector signals
    //             for I3C. These must always follow SCL/SDA and the muxing must also be active in
    //             deep sleep. Defining the reset detector signals as followers of SCL/SDA ensures
    //             they always stay in sync. It also ensures that the muxing is active in deep
    //             sleep as in this particular case the muxing is duplicated in both pinmux
    //             partitions.
    //
    //             An empty string generates the INSEL mux of this signal in both partitions, so
    //             both partitions provide the mux result. This is useful when directly tapping
    //             into the mux results, see for example the USB wakeup detector inside the
    //             pinmux.
    //
    // - desc: Optional description field.
    //
    // - attr: Manual direct IOs may specify an additional pad attr field.
    //         This is used to create the correct pad attribute CSR for that DIO channel (since the
    //         DIO is manual, there is no way to automatically infer the corresponding pad type).
    //         Not to be confused with the 'attrs' key of a pad.
    //
    signals: [
      // USB
      { instance: 'usbdev',      port: 'usb_dp',           connection: 'manual', pads: [],                                       desc: ''},
      { instance: 'usbdev',      port: 'usb_dn',           connection: 'manual', pads: [],                                       desc: ''},
      { instance: 'usbdev',      port: 'sense',            connection: 'muxed',  pads: ['IOC7', 'IOC12', 'IOR11'], follower: '', desc: ''},
      // SPI Host0
      { instance: 'spi_host0',   port: 'sck',              connection: 'muxed',  pads: ['SPI_HOST_CLK'],  default: 'SPI_HOST_CLK',  desc: ''},
      { instance: 'spi_host0',   port: 'csb[0]',           connection: 'muxed',  pads: ['SPI_HOST_CS_L'], default: 'SPI_HOST_CS_L', desc: ''},
      { instance: 'spi_host0',   port: 'csb[1]',           connection: 'muxed',  pads: ['IOA2', 'IOA5'],                            desc: ''},
      { instance: 'spi_host0',   port: 'csb[2]',           connection: 'muxed',  pads: ['IOA3', 'IOA4'],                            desc: ''},
      { instance: 'spi_host0',   port: 'sd[0]',            connection: 'muxed',  pads: ['SPI_HOST_D0'],   default: 'SPI_HOST_D0',   desc: ''},
      { instance: 'spi_host0',   port: 'sd[1]',            connection: 'muxed',  pads: ['SPI_HOST_D1'],   default: 'SPI_HOST_D1',   desc: ''},
      { instance: 'spi_host0',   port: 'sd[2]',            connection: 'muxed',  pads: ['SPI_HOST_D2'],   default: 'SPI_HOST_D2',   desc: ''},
      { instance: 'spi_host0',   port: 'sd[3]',            connection: 'muxed',  pads: ['SPI_HOST_D3'],   default: 'SPI_HOST_D3',   desc: ''},
      // SPI Host 1
      { instance: "spi_host1",   port: 'sck',              connection: 'muxed',  pads: ['IOB3'],         desc: ''},
      { instance: "spi_host1",   port: 'csb[0]',           connection: 'muxed',  pads: ['IOB0'],         desc: ''},
      { instance: "spi_host1",   port: 'csb[1]',           connection: 'muxed',  pads: ['IOB5'],         desc: ''},
      { instance: "spi_host1",   port: 'csb[2]',           connection: 'muxed',  pads: ['IOB7', 'IOB8'], desc: ''},
      { instance: "spi_host1",   port: 'sd[0]',            connection: 'muxed',  pads: ['IOB1'],         desc: ''},
      { instance: "spi_host1",   port: 'sd[1]',            connection: 'muxed',  pads: ['IOB2'],         desc: ''},
      { instance: "spi_host1",   port: 'sd[2]',            connection: 'muxed',  pads: ['IOB4'],         desc: ''},
      { instance: "spi_host1",   port: 'sd[3]',            connection: 'muxed',  pads: ['IOB6'],         desc: ''},
      // SPI Device
      { instance: 'spi_device',  port: 'sck',              connection: 'muxed',  pads: ['SPI_DEV_CLK'],          default: 'SPI_DEV_CLK',  desc: ''},
      { instance: 'spi_device',  port: 'csb',              connection: 'muxed',  pads: ['SPI_DEV_CS_L'],         default: 'SPI_DEV_CS_L', desc: ''},
      { instance: "spi_device",  port: 'tpm_csb',          connection: 'muxed',  pads: ['IOA2', 'IOA4', 'IOA7'],                          desc: ''},
      { instance: 'spi_device',  port: 'sd[0]',            connection: 'muxed',  pads: ['SPI_DEV_D0'],           default: 'SPI_DEV_D0',   desc: ''},
      { instance: 'spi_device',  port: 'sd[1]',            connection: 'muxed',  pads: ['SPI_DEV_D1'],           default: 'SPI_DEV_D1',   desc: ''},
      { instance: 'spi_device',  port: 'sd[2]',            connection: 'muxed',  pads: ['SPI_DEV_D2'],           default: 'SPI_DEV_D2',   desc: ''},
      { instance: 'spi_device',  port: 'sd[3]',            connection: 'muxed',  pads: ['SPI_DEV_D3'],           default: 'SPI_DEV_D3',   desc: ''},
      // GPIOs
      { instance: "gpio0",       port: 'gpio[0]',          connection: 'muxed',  pads: ['SPI_HOST_D0'],   desc: ''},
      { instance: "gpio0",       port: 'gpio[1]',          connection: 'muxed',  pads: ['SPI_HOST_D1'],   desc: ''},
      { instance: "gpio0",       port: 'gpio[2]',          connection: 'muxed',  pads: ['SPI_HOST_D2'],   desc: ''},
      { instance: "gpio0",       port: 'gpio[3]',          connection: 'muxed',  pads: ['SPI_HOST_D3'],   desc: ''},
      { instance: "gpio0",       port: 'gpio[4]',          connection: 'muxed',  pads: ['SPI_HOST_CLK'],  desc: ''},
      { instance: "gpio0",       port: 'gpio[5]',          connection: 'muxed',  pads: ['SPI_HOST_CS_L'], desc: ''},
      { instance: "gpio0",       port: 'gpio[6]',          connection: 'muxed',  pads: ['SPI_DEV_D0'],    desc: ''},
      { instance: "gpio0",       port: 'gpio[7]',          connection: 'muxed',  pads: ['SPI_DEV_D1'],    desc: ''},
      { instance: "gpio0",       port: 'gpio[8]',          connection: 'muxed',  pads: ['SPI_DEV_D2'],    desc: ''},
      { instance: "gpio0",       port: 'gpio[9]',          connection: 'muxed',  pads: ['SPI_DEV_D3'],    desc: ''},
      { instance: "gpio0",       port: 'gpio[10]',         connection: 'muxed',  pads: ['SPI_DEV_CLK'],   desc: ''},
      { instance: "gpio0",       port: 'gpio[11]',         connection: 'muxed',  pads: ['SPI_DEV_CS_L'],  desc: ''},
      { instance: "gpio0",       port: 'gpio[12]',         connection: 'muxed',  pads: ['IOA0'],          desc: ''},
      { instance: "gpio0",       port: 'gpio[13]',         connection: 'muxed',  pads: ['IOA1'],          desc: ''},
      { instance: "gpio0",       port: 'gpio[14]',         connection: 'muxed',  pads: ['IOA2'],          desc: ''},
      { instance: "gpio0",       port: 'gpio[15]',         connection: 'muxed',  pads: ['IOA3'],          desc: ''},
      { instance: "gpio0",       port: 'gpio[16]',         connection: 'muxed',  pads: ['IOA4'],          desc: ''},
      { instance: "gpio0",       port: 'gpio[17]',         connection: 'muxed',  pads: ['IOA5'],          desc: ''},
      { instance: "gpio0",       port: 'gpio[18]',         connection: 'muxed',  pads: ['IOA6'],          desc: ''},
      { instance: "gpio0",       port: 'gpio[19]',         connection: 'muxed',  pads: ['IOA7'],          desc: ''},
      { instance: "gpio0",       port: 'gpio[20]',         connection: 'muxed',  pads: ['IOA8'],          desc: ''},
      { instance: "gpio0",       port: 'gpio[21]',         connection: 'muxed',  pads: ['IOB0'],          desc: ''},
      { instance: "gpio0",       port: 'gpio[22]',         connection: 'muxed',  pads: ['IOB1'],          desc: ''},
      { instance: "gpio0",       port: 'gpio[23]',         connection: 'muxed',  pads: ['IOB2'],          desc: ''},
      { instance: "gpio0",       port: 'gpio[24]',         connection: 'muxed',  pads: ['IOB3'],          desc: ''},
      { instance: "gpio0",       port: 'gpio[25]',         connection: 'muxed',  pads: ['IOB4'],          desc: ''},
      { instance: "gpio0",       port: 'gpio[26]',         connection: 'muxed',  pads: ['IOB5'],          desc: ''},
      { instance: "gpio0",       port: 'gpio[27]',         connection: 'muxed',  pads: ['IOB6'],          desc: ''},
      { instance: "gpio0",       port: 'gpio[28]',         connection: 'muxed',  pads: ['IOB7'],          desc: ''},
      { instance: "gpio0",       port: 'gpio[29]',         connection: 'muxed',  pads: ['IOB8'],          desc: ''},
      { instance: "gpio0",       port: 'gpio[30]',         connection: 'muxed',  pads: ['IOB9'],          desc: ''},
      { instance: "gpio0",       port: 'gpio[31]',         connection: 'muxed',  pads: ['IOB10'],         desc: ''},
      { instance: "gpio1",       port: 'gpio[0]',          connection: 'muxed',  pads: ['IOB11'],         desc: ''},
      { instance: "gpio1",       port: 'gpio[1]',          connection: 'muxed',  pads: ['IOB12'],         desc: ''},
      { instance: "gpio1",       port: 'gpio[2]',          connection: 'muxed',  pads: ['IOC0'],          desc: ''},
      { instance: "gpio1",       port: 'gpio[3]',          connection: 'muxed',  pads: ['IOC1'],          desc: ''},
      { instance: "gpio1",       port: 'gpio[4]',          connection: 'muxed',  pads: ['IOC2'],          desc: ''},
      { instance: "gpio1",       port: 'gpio[5]',          connection: 'muxed',  pads: ['IOC3'],          desc: ''},
      { instance: "gpio1",       port: 'gpio[6]',          connection: 'muxed',  pads: ['IOC4'],          desc: ''},
      { instance: "gpio1",       port: 'gpio[7]',          connection: 'muxed',  pads: ['IOC5'],          desc: ''},
      { instance: "gpio1",       port: 'gpio[8]',          connection: 'muxed',  pads: ['IOC6'],          desc: ''},
      { instance: "gpio1",       port: 'gpio[9]',          connection: 'muxed',  pads: ['IOC7'],          desc: ''},
      { instance: "gpio1",       port: 'gpio[10]',         connection: 'muxed',  pads: ['IOC8'],          desc: ''},
      { instance: "gpio1",       port: 'gpio[11]',         connection: 'muxed',  pads: ['IOC9'],          desc: ''},
      { instance: "gpio1",       port: 'gpio[12]',         connection: 'muxed',  pads: ['IOC10'],         desc: ''},
      { instance: "gpio1",       port: 'gpio[13]',         connection: 'muxed',  pads: ['IOC11'],         desc: ''},
      { instance: "gpio1",       port: 'gpio[14]',         connection: 'muxed',  pads: ['IOC12'],         desc: ''},
      { instance: "gpio1",       port: 'gpio[15]',         connection: 'muxed',  pads: ['IOR0'],          desc: ''},
      { instance: "gpio1",       port: 'gpio[16]',         connection: 'muxed',  pads: ['IOR1'],          desc: ''},
      { instance: "gpio1",       port: 'gpio[17]',         connection: 'muxed',  pads: ['IOR2'],          desc: ''},
      { instance: "gpio1",       port: 'gpio[18]',         connection: 'muxed',  pads: ['IOR3'],          desc: ''},
      { instance: "gpio1",       port: 'gpio[19]',         connection: 'muxed',  pads: ['IOR4'],          desc: ''},
      { instance: "gpio1",       port: 'gpio[20]',         connection: 'muxed',  pads: ['IOR5'],          desc: ''},
      { instance: "gpio1",       port: 'gpio[21]',         connection: 'muxed',  pads: ['IOR6'],          desc: ''},
      { instance: "gpio1",       port: 'gpio[22]',         connection: 'muxed',  pads: ['IOR7'],          desc: ''},
      { instance: "gpio1",       port: 'gpio[23]',         connection: 'muxed',  pads: ['IOR8'],          desc: ''},
      { instance: "gpio1",       port: 'gpio[24]',         connection: 'muxed',  pads: ['IOR9'],          desc: ''},
      { instance: "gpio1",       port: 'gpio[25]',         connection: 'muxed',  pads: ['IOR10'],         desc: ''},
      { instance: "gpio1",       port: 'gpio[26]',         connection: 'muxed',  pads: ['IOR11'],         desc: ''},
      { instance: "gpio1",       port: 'gpio[27]',         connection: 'muxed',  pads: ['IOR12'],         desc: ''},
      { instance: "gpio1",       port: 'gpio[28]',         connection: 'muxed',  pads: ['IOR13'],         desc: ''},
      // TODO: These GPIOs are just mapped to already have their indices. Final location is not yet defined.
      { instance: "gpio1",       port: 'gpio[29]',         connection: 'muxed',  pads: ['IOR10'],         desc: ''},
      { instance: "gpio1",       port: 'gpio[30]',         connection: 'muxed',  pads: ['IOR11'],         desc: ''},
      { instance: "gpio1",       port: 'gpio[31]',         connection: 'muxed',  pads: ['IOR12'],         desc: ''},
      // UARTs
      { instance: "uart0",       port: 'rx',               connection: 'muxed',  pads: ['IOA2',  'IOC3'],  desc: ''},
      { instance: "uart0",       port: 'tx',               connection: 'muxed',  pads: ['IOA3',  'IOC4'],  desc: ''},
      { instance: "uart1",       port: 'rx',               connection: 'muxed',  pads: ['IOA0',  'IOR5'],  desc: ''},
      { instance: "uart1",       port: 'tx',               connection: 'muxed',  pads: ['IOA1',  'IOR6'],  desc: ''},
      { instance: "uart2",       port: 'rx',               connection: 'muxed',  pads: ['IOB4',  'IOC10'], desc: ''},
      { instance: "uart2",       port: 'tx',               connection: 'muxed',  pads: ['IOB5',  'IOC11'], desc: ''},
      { instance: "uart3",       port: 'rx',               connection: 'muxed',  pads: ['IOA4',  'IOR3'],  desc: ''},
      { instance: "uart3",       port: 'tx',               connection: 'muxed',  pads: ['IOA5',  'IOR4'],  desc: ''},
      // I2Cs
      { instance: "i2c0",        port: 'sda',              connection: 'muxed',  pads: ['IOA7',  'IOB10', 'IOR13'],          desc: ''},
      { instance: "i2c0",        port: 'scl',              connection: 'muxed',  pads: ['IOA8',  'IOB9',  'IOR12'],          desc: ''},
      { instance: "i2c1",        port: 'sda',              connection: 'muxed',  pads: ['IOB11', 'IOB12', 'IOR11'],          desc: ''},
      { instance: "i2c1",        port: 'scl',              connection: 'muxed',  pads: ['IOB11', 'IOB12', 'IOR10'],          desc: ''},
      { instance: "i2c2",        port: 'sda',              connection: 'muxed',  pads: ['IOA7',  'IOB9',  'IOB10', 'IOC12'], desc: ''},
      { instance: "i2c2",        port: 'scl',              connection: 'muxed',  pads: ['IOA8',  'IOB9',  'IOB10', 'IOC9'],  desc: ''},
      // I3Cs
      { instance: "i3c0",        port: 'scl',              connection: 'muxed',  pads: ['IOA8',  'IOB11', 'IOR12'], desc: ''},
      { instance: "i3c0",        port: 'sda',              connection: 'muxed',  pads: ['IOA7',  'IOB12', 'IOR13'], desc: ''},
      { instance: "i3c0",        port: 'ctrl_sda_pu',      connection: 'muxed',  pads: ['IOA2',  'IOB8',  'IOR7'],  desc: ''},
      { instance: "i3c0",        port: 'rstdet_scl',       connection: 'muxed',  pads: ['IOA8',  'IOB11', 'IOR12'], desc: ''}, // Same as SCL. TODO: Implement wakeup mux
      { instance: "i3c0",        port: 'rstdet_sda',       connection: 'muxed',  pads: ['IOA7',  'IOB12', 'IOR13'], desc: ''}, // Same as SDA. TODO: Implement wakeup mux
      { instance: "i3c1",        port: 'scl',              connection: 'muxed',  pads: ['IOB9',  'IOB11', 'IOR10'], desc: ''},
      { instance: "i3c1",        port: 'sda',              connection: 'muxed',  pads: ['IOB10', 'IOB12', 'IOR11'], desc: ''},
      { instance: "i3c1",        port: 'ctrl_sda_pu',      connection: 'muxed',  pads: ['IOB7',  'IOB10', 'IOR2'],  desc: ''},
      { instance: "i3c1",        port: 'rstdet_scl',       connection: 'muxed',  pads: ['IOB9',  'IOB11', 'IOR10'], desc: ''}, // Same as SCL. TODO: Implement wakeup mux
      { instance: "i3c1",        port: 'rstdet_sda',       connection: 'muxed',  pads: ['IOB10', 'IOB12', 'IOR11'], desc: ''}, // Same as SDA. TODO: Implement wakeup mux
      // AST / sensor_ctrl
      { instance: "sensor_ctrl", port: 'ast_debug_out[0]', connection: 'muxed',  pads: ['IOA7'],        desc: ''},
      { instance: "sensor_ctrl", port: 'ast_debug_out[1]', connection: 'muxed',  pads: ['IOA8'],        desc: ''},
      { instance: "sensor_ctrl", port: 'ast_debug_out[2]', connection: 'muxed',  pads: ['SPI_HOST_D3'], desc: ''},
      { instance: "sensor_ctrl", port: 'ast_debug_out[3]', connection: 'muxed',  pads: ['IOC1'],        desc: ''},
      { instance: "sensor_ctrl", port: 'ast_debug_out[4]', connection: 'muxed',  pads: ['IOC2'],        desc: ''},
      { instance: "sensor_ctrl", port: 'ast_debug_out[5]', connection: 'muxed',  pads: ['IOC0'],        desc: ''},
      { instance: "sensor_ctrl", port: 'ast_debug_out[6]', connection: 'muxed',  pads: ['IOC4'],        desc: ''},
      { instance: "sensor_ctrl", port: 'ast_debug_out[7]', connection: 'muxed',  pads: ['IOC3'],        desc: ''},
      // Sysrst ctrl
      { instance: "sysrst_ctrl", port: 'ac_present',       connection: 'muxed',  pads: ['IOR2'],                   desc: ''},
      { instance: "sysrst_ctrl", port: 'key0_in',          connection: 'muxed',  pads: ['IOR1'],                   desc: ''},
      { instance: "sysrst_ctrl", port: 'key1_in',          connection: 'muxed',  pads: ['IOR3'],                   desc: ''},
      { instance: "sysrst_ctrl", port: 'key2_in',          connection: 'muxed',  pads: ['IOR5'],                   desc: ''},
      { instance: "sysrst_ctrl", port: 'pwrb_in',          connection: 'muxed',  pads: ['IOR0'],                   desc: ''},
      { instance: "sysrst_ctrl", port: 'bat_disable',      connection: 'muxed',  pads: ['IOR12'],                  desc: ''},
      { instance: "sysrst_ctrl", port: 'ec_rst_l',         connection: 'muxed',  pads: ['IOR8'],  default: 'IOR8', desc: ''},
      { instance: "sysrst_ctrl", port: 'flash_wp_l',       connection: 'muxed',  pads: ['IOR9'],  default: 'IOR9', desc: ''},
      { instance: "sysrst_ctrl", port: 'key0_out',         connection: 'muxed',  pads: ['IOR6'],                   desc: ''},
      { instance: "sysrst_ctrl", port: 'key1_out',         connection: 'muxed',  pads: ['IOR13'],                  desc: ''},
      { instance: "sysrst_ctrl", port: 'key2_out',         connection: 'muxed',  pads: ['IOR7'],                   desc: ''},
      { instance: "sysrst_ctrl", port: 'pwrb_out',         connection: 'muxed',  pads: ['IOR10'],                  desc: ''},
      { instance: "sysrst_ctrl", port: 'lid_open',         connection: 'muxed',  pads: ['IOR11'],                  desc: ''},
      { instance: "sysrst_ctrl", port: 'z3_wakeup',        connection: 'muxed',  pads: ['IOR4'],                   desc: ''},
    ],

    num_wkup_detect: 8,
    wkup_cnt_width:  8,
    // Enable USB wakeup and hardware strap sampling for discrete OpenTitan
    enable_usb_wakeup: true
    enable_strap_sampling: true
    // RRAM TAP, enabled on the TAP strap value 0 by the RRAM_JTAG_SEL register
    enable_rram_tap: true
  },

  // Implementation targets.
  // This defines the configuration of the target-specific chip-levels  to
  // generate from the shared template. Each target uses the same base
  // configuration for the  pinmux and pinout as defined above, and the
  // generated software constants for the pinmux DIF do not change among the
  // implementation targets. However, in order to accommodate slight
  // differences among the ASIC, FPGA emulation and simulation environments,
  // it is possible to make very limited pinout changes below. In particular,
  // it is possible to remove and tie-off specific pads, or add more 'manual'
  // pads that need to be manually connected in the template. It is also possible
  // to override the JTAG and strap locations indices, since the testing and DFT
  // setups may differ among the targets.
  targets: [
    { name: 'asic',

      // Chip level changes
      chiplevel: {
        port_overrides: {
          'rram_macro.rram_test_analog'     : { signal: 'RRAM_ANALOG'     },
          'usbdev.usb_rx_d'                 : { signal: 'usb_rx_d'        },
          'usbdev.usb_rx_enable'            : { signal: 'usb_rx_enable'   },
          'usbdev.usb_tx_d'                 : { unused: true              },
          'usbdev.usb_tx_se0'               : { unused: true              },
          'usbdev.usb_tx_use_d_se0'         : { unused: true              },
          'pinmux.dft_hold_tap_sel'         : { unused: true              },
          'pinmux.usb_dppullup_en'          : { signal: 'usb_dp_pullup_en'},
          'pinmux.usb_dnpullup_en'          : { signal: 'usb_dn_pullup_en'},
          'ast.scan_shift_en'               : { unused: true              },
          'ast.scan_reset_n'                : { unused: true              },
        }
      },

      // Pinout Changes.
      pinout: {
        // This is a list of port names to remove from the chip port list.
        // The corresponding pad of a removed port will remain instantiated,
        // and a wire net will be declared inside the chip-level hierarchy so
        // that it can be manually connected as needed.
        remove_ports: [],

        // This is a list of pad names to remove from the base pinout defined
        // above. Removed pads will be stubbed off such that their inputs
        // signals are driven  with zero. Output signals and output enables
        // will be left unconnected. If no changes are needed, this list can
        // be left empty.
        remove_pads: [],

        // This is a list of additional "manual" pads to add to the pinout.
        // The pad entries have the same format as the pad entries in the pinout
        // configuration above. However, the 'connection' key must always be set
        // to 'manual' as it is not possible to connect these additional pads
        // to the pinmux or peripherals.
        add_pads: [],
      },

      pinmux: {
        // Special signal positions. Each entry in the list below creates a
        // target-specific pad position parameter in the  chiplevel hierarchy
        // that can be used to parameterize certain IPs like the pinmux or
        // padring. This is mainly used to define the pad positions of special
        // test and DFT signals such as the JTAG signals and the TAP and DFT
        // straps. Straps in this context are special pads that get sampled at
        // boot time during certain life cycle states in order to determine
        // DFT modes and the TAP mux selection index (the JTAG signals can be
        // muxed to either the lifecycle TAP, DFT TAP or RISC-V processor
        // TAP). TODO: add more documentation to
        // https://opentitan.org/book/hw/top_earlgrey/ip_autogen/pinmux/index.html
        // Each entry must have the following two keys:
        //
        // - name: Basename for the SV parameter.
        //
        // - pad: The pad name that this special signal maps to. The generated
        //        parameter will be assigned the corresponding pad index.
        //
        // Each entry may have an optional 'desc' key for further description.
        special_signals: [
          // Straps
          // Check pad attributes if strap pins change.
          { name: 'tap0',   pad: 'IOC8',        desc: 'TAP strap signal.'   },
          { name: 'tap1',   pad: 'IOC5',        desc: 'TAP strap signal.'   },
          { name: 'dft0',   pad: 'SPI_HOST_D2', desc: 'DFT strap signal.'   },
          { name: 'dft1',   pad: 'SPI_HOST_D3', desc: 'DFT strap signal.'   },
          // JTAG
          { name: 'tck',    pad: 'IOA5', desc: 'JTAG tck signal.'    },
          { name: 'tms',    pad: 'IOA0', desc: 'JTAG tms signal.'    },
          { name: 'trst_n', pad: 'IOA6', desc: 'JTAG trst_n signal.' },
          { name: 'tdi',    pad: 'IOA4', desc: 'JTAG tdi signal.'    },
          { name: 'tdo',    pad: 'IOA1', desc: 'JTAG tdo signal.'    },
        ],
      }
    },
    { name: 'verilator',

      // The verilator chip-level has no physical pads: the flat per-peripheral
      // signals are connected to the testbench DPI models through the
      // padring_verilator module. Most signals therefore flow through the
      // common (shared with ASIC) path, except:
      //  - the USB tx signals, which are observed by the usbdpi model
      //  - the OTP IO (bidir) test pad
      chiplevel: {
        port_overrides: {
          // These are inout pads on the ASIC; the verilator target has no pads,
          // so leave them open (empty connection) rather than tying them off
          // ('0 on a multi-bit inout is rejected by Verilator).
          'rram_macro.rram_test_analog'     : { unused: true, tie_value: "" },
          'sensor_ctrl.manual_pad_attr'     : { unused: true                },
          'usbdev.usb_rx_d'                 : { signal: 'usb_rx_d'          },
          'usbdev.usb_rx_enable'            : { signal: 'usb_rx_enable'     },
          'usbdev.usb_tx_d'                 : { signal: 'usb_tx_d'          },
          'usbdev.usb_tx_se0'               : { signal: 'usb_tx_se0'        },
          'usbdev.usb_tx_use_d_se0'         : { signal: 'usb_tx_use_d_se0'  },
          'pinmux.dft_hold_tap_sel'         : { unused: true                },
          'pinmux.usb_dppullup_en'          : { signal: 'usb_dp_pullup_en'  },
          'pinmux.usb_dnpullup_en'          : { signal: 'usb_dn_pullup_en'  },
          'ast.por_n'                       : { signal: 'rst_n'             },
          'ast.pora_n'                      : { signal: 'rst_n'             },
          'ast.scan_shift_en'               : { unused: true                },
          'ast.scan_reset_n'                : { unused: true                },
          'ast.usb_io_pu_cal'               : { unused: true                },
        }
      },

      // Pinout Changes.
      // The verilator target has no physical pads, so there is nothing to
      // remove or add here.
      pinout: {
        remove_ports: [],
        remove_pads: [],
        add_pads: [],
      },

      pinmux: {
        // Same special signal (JTAG / strap) positions as the ASIC target to
        // keep PinmuxTargetCfg in chiplevel identical; not actually relevant.
        special_signals: [
          // Straps
          // Check pad attributes if strap pins change.
          { name: 'tap0',   pad: 'IOC8',        desc: 'TAP strap signal.'   },
          { name: 'tap1',   pad: 'IOC5',        desc: 'TAP strap signal.'   },
          { name: 'dft0',   pad: 'SPI_HOST_D2', desc: 'DFT strap signal.'   },
          { name: 'dft1',   pad: 'SPI_HOST_D3', desc: 'DFT strap signal.'   },
          // JTAG
          { name: 'tck',    pad: 'IOA5', desc: 'JTAG tck signal.'    },
          { name: 'tms',    pad: 'IOA0', desc: 'JTAG tms signal.'    },
          { name: 'trst_n', pad: 'IOA6', desc: 'JTAG trst_n signal.' },
          { name: 'tdi',    pad: 'IOA4', desc: 'JTAG tdi signal.'    },
          { name: 'tdo',    pad: 'IOA1', desc: 'JTAG tdo signal.'    },
        ],
      }
    },
    { name: 'cw340',

      // Chip level changes
      chiplevel: {
        port_overrides: {
          'pinmux.dft_hold_tap_sel'         : { unused: true },
          'pinmux.usb_dppullup_en'          : { signal: 'usb_dp_pullup_en' },
          'pinmux.usb_dnpullup_en'          : { unused: true },
          'usbdev.usb_tx_d'                 : { unused: true },
          'usbdev.usb_tx_se0'               : { unused: true },
          'usbdev.usb_tx_use_d_se0'         : { unused: true },
          'usbdev.usb_rx_d'                 : { signal: 'usb_rx_d'      },
          'usbdev.usb_rx_enable'            : { signal: 'usb_rx_enable' },
          'sensor_ctrl.manual_pad_attr'     : { unused: true },
          'rram_macro.rram_test_analog'     : { unused: true },
          'ast.por_n'                       : { signal: 'rst_n' },
          'ast.pora_n'                      : { signal: 'rst_n' },
          'ast.scan_shift_en'               : { unused: true },
          'ast.scan_reset_n'                : { unused: true },
          'ast.usb_io_pu_cal'               : { unused: true },
        }
      }

      pinout: {
        remove_ports: [],
        remove_pads: [
          // The FPGA reset is solely based on POR_N
          'PORA_N',
          'CC1', 'CC2',
          'RRAM_ANALOG',
          'USB_P', 'USB_N'
        ],

        add_pads: [
          // Additional infrastructure pads
          { name: 'IO_CLK',           type: 'InputStd', bank: 'VCC', connection: 'manual', desc: 'Extra clock input for FPGA target'}
          // Custom USB pads
          { name: 'IO_USB_CONNECT',  type: 'BidirStd', bank: 'VCC', connection: 'manual', desc: 'Manual USB UPHY signal for FPGA target'}
          { name: 'IO_USB_DP_TX',    type: 'BidirStd', bank: 'VCC', connection: 'manual', desc: 'Manual USB UPHY signal for FPGA target'}
          { name: 'IO_USB_DN_TX',    type: 'BidirStd', bank: 'VCC', connection: 'manual', desc: 'Manual USB UPHY signal for FPGA target'}
          { name: 'IO_USB_D_RX',     type: 'BidirStd', bank: 'VCC', connection: 'manual', desc: 'Manual USB UPHY signal for FPGA target'}
          { name: 'IO_USB_DP_RX',    type: 'BidirStd', bank: 'VCC', connection: 'manual', desc: 'Manual USB UPHY signal for FPGA target'}
          { name: 'IO_USB_DN_RX',    type: 'BidirStd', bank: 'VCC', connection: 'manual', desc: 'Manual USB UPHY signal for FPGA target'}
          { name: 'IO_USB_OE_N',     type: 'BidirStd', bank: 'VCC', connection: 'manual', desc: 'Manual USB UPHY signal for FPGA target'}
          { name: 'IO_USB_SPEED',    type: 'BidirStd', bank: 'VCC', connection: 'manual', desc: 'Manual USB UPHY signal for FPGA target'}
          { name: 'IO_USB_SUSPEND',  type: 'BidirStd', bank: 'VCC', connection: 'manual', desc: 'Manual USB UPHY signal for FPGA target'}
          // ChipWhisperer IO
          { name: 'IO_CLKOUT',        type: 'BidirStd', bank: 'VCC', connection: 'manual', desc: 'Manual clock output for SCA setup'}
          { name: 'IO_TRIGGER',       type: 'BidirStd', bank: 'VCC', connection: 'manual', desc: 'Manual trigger output for SCA setup'}
        ],
      },

      pinmux: {
        special_signals: [
          // Straps
          // Check pad attributes if strap pins change.
          { name: 'tap0',   pad: 'IOC8',        desc: 'TAP strap signal.'   },
          { name: 'tap1',   pad: 'IOC5',        desc: 'TAP strap signal.'   },
          { name: 'dft0',   pad: 'SPI_HOST_D2', desc: 'DFT strap signal.'   },
          { name: 'dft1',   pad: 'SPI_HOST_D3', desc: 'DFT strap signal.'   },
          // JTAG
          { name: 'tck',    pad: 'IOA5', desc: 'JTAG tck signal.'    },
          { name: 'tms',    pad: 'IOA0', desc: 'JTAG tms signal.'    },
          { name: 'trst_n', pad: 'IOA6', desc: 'JTAG trst_n signal.' },
          { name: 'tdi',    pad: 'IOA4', desc: 'JTAG tdi signal.'    },
          { name: 'tdo',    pad: 'IOA1', desc: 'JTAG tdo signal.'    },
        ],
      }
    }
  ]
}
