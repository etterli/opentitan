// Copyright lowRISC contributors (OpenTitan project).
// Licensed under the Apache License, Version 2.0, see LICENSE for details.
// SPDX-License-Identifier: Apache-2.0
//#############################################################################
// *Name: ast
// *Module Description: Analog Sensors Top Registers
//#############################################################################
{ name:               "ast",
  // Unique comportable IP identifier defined under KNOWN_CIP_IDS in the regtool.
  cip_id:             "34",
  design_spec:        "../doc",
  dv_doc:             "",
  hw_checklist:       "",
  sw_checklist:       "",
  version:            "2.0.0",
  life_stage:         "L1",
  design_stage:       "D1",
  verification_stage: "V2S",
  dif_stage:          "",
  is_split_ip: "true",
  clocking: {
    primary: [
      { clock: "clk_ast_tlul_i",  reset: "rst_ast_tlul_ni", primary: true },
      { clock: "clk_ast_es_i",    reset: "rst_ast_es_ni"},
      { clock: "clk_ast_usb_i",   reset: "rst_ast_usb_ni"},
      // Unmanaged external clock from a pad for FPGA.
      { clock: "clk_ast_ext_i"},
    ],
    secondary: [
      { clock: "clk_ast_adc_i",   reset: "rst_ast_adc_ni"},
      // Primary clock because it controls alerts.
      { clock: "clk_ast_alert_i", reset: "rst_ast_alert_ni", primary: true},
      { clock: "clk_ast_es_i",    reset: "rst_ast_es_ni"},
      { clock: "clk_ast_rng_i",   reset: "rst_ast_rng_ni"},
      { clock: "clk_ast_tlul_i",  reset: "rst_ast_tlul_ni" },
      { clock: "clk_ast_usb_i",   reset: "rst_ast_usb_ni"},
      // Unmanaged external clock from a pad for FPGA.
      { clock: "clk_ast_ext_i"},
    ],
  },
  bus_interfaces: [
    { protocol: "tlul",
      direction: "device"
    }
  ],
  param_list: [
    { name:    "NumRegsB",
      desc: "Number of registers in the Array-B",
      type:    "int",
      default: "5",
      local:   "true",
    },
    { name: "NumUsbBeaconPulses",
      desc: "Number of USB valid beacon pulses for clock to re-calibrate",
      type: "int",
      default: "8",
      local: "true"
    },
    { name:    "EntropyStreams",
      desc:    "Number of entropy streams",
      type:    "int unsigned",
      default: "4",
      local:   "false",
      expose:  "true",
    },
    // Secondary-partition width parameters. Each defaults to its ast_pkg value
    // and is checked against it by an ASSERT_INIT in ast_part_secondary.
    { name:    "UsbCalibWidth",
      desc:    "Width of the USB IO pull-up calibration setting",
      type:    "int unsigned",
      default: "20",
      local:   "false",
      expose:  "true",
      partition: "secondary",
    },
    { name:    "AdcChannels",
      desc:    "Number of ADC channels",
      type:    "int unsigned",
      default: "2",
      local:   "true",
      expose:  "true",
      partition: "secondary",
    },
    { name:    "AdcDataWidth",
      desc:    "Width of the ADC digital output",
      type:    "int unsigned",
      default: "10",
      local:   "true",
      expose:  "true",
      partition: "secondary",
    },
    { name:    "Pad2AstInWidth",
      desc:    "Width of the pad-to-AST input bus",
      type:    "int unsigned",
      default: "8",
      local:   "false",
      expose:  "true",
      partition: "secondary",
    },
    { name:    "Ast2PadOutWidth",
      desc:    "Width of the AST-to-pad output bus",
      type:    "int unsigned",
      default: "9",
      local:   "false",
      expose:  "true",
      partition: "secondary",
    },
  ],
  // interrupt_list: [],
  // No alerts as AST's analog alert events are delivered to sensor_ctrl.
  inter_signal_list: [
    ///////////////////////
    // Primary partition //
    ///////////////////////
    // AST (registers) init done
    { struct:  "mubi4",
      type:    "uni",
      name:    "ast_init_done",
      width:   "1",
      act:     "req",
      package: "prim_mubi_pkg",
    },
    // RNG interface
    { struct:  "logic",
      type:    "uni",
      name:    "rng_en",
      act:     "rcv",
    },
    { struct:  "logic",
      type:    "uni",
      name:    "rng_fips",
      act:     "rcv",
    },
    { struct:  "logic",
      type:    "uni",
      name:    "rng_val",
      act:     "req",
    },
    { struct:  "logic",
      type:    "uni",
      name:    "rng_b",
      act:     "req",
      width:   "EntropyStreams",
    },
    // Entropy interface
    { struct:  "edn",
      type:    "req_rsp",
      name:    "entropy",
      act:     "req",
      package: "edn_pkg",
    },
    // Clock source system jitter enable
    { struct:  "mubi4",
      type:    "uni",
      name:    "clk_src_sys_jen",
      width:   "1",
      act:     "rcv",
      package: "prim_mubi_pkg",
    },
    // IO clock bypass request
    { struct:  "mubi4",
      type:    "uni",
      name:    "io_clk_byp_req",
      width:   "1",
      act:     "rcv",
      package: "prim_mubi_pkg",
    },
    // All clock bypass request
    { struct:  "mubi4",
      type:    "uni",
      name:    "all_clk_byp_req",
      width:   "1",
      act:     "rcv",
      package: "prim_mubi_pkg",
    },
    // Ext. frequency is 96MHz
    { struct:  "mubi4",
      type:    "uni",
      name:    "ext_freq_is_96m",
      width:   "1",
      act:     "rcv",
      package: "prim_mubi_pkg",
    },
    { struct:  "clks_osc_byp",
      type:    "uni",
      name:    "clk_osc_byp",
      act:     "rcv",
      package: "ast_pkg",
    },
    // Clock source system
    { struct: "logic",
      type:    "uni",
      name:    "clk_src_sys",
      act:     "req",
    },
    // Clock source IO
    { struct: "logic",
      type:    "uni",
      name:    "clk_src_io",
      act:     "req",
    },
    // Clock source IO 48MHz
    { struct:  "mubi4",
      type:    "uni",
      name:    "clk_src_io_48m",
      width:   "1",
      act:     "req",
      package: "prim_mubi_pkg",
    },
    // Clock source USB
    { struct: "logic",
      type:    "uni",
      name:    "clk_src_usb",
      act:     "req",
    },
    // IO clock bypass ack
    { struct:  "mubi4",
      type:    "uni",
      name:    "io_clk_byp_ack",
      width:   "1",
      act:     "req",
      package: "prim_mubi_pkg",
    },
    // All clock bypass ack
    { struct:  "mubi4",
      type:    "uni",
      name:    "all_clk_byp_ack",
      width:   "1",
      act:     "req",
      package: "prim_mubi_pkg",
    },
    /////////////////////////
    // Secondary partition //
    /////////////////////////
    { struct:    "logic",
      type:      "uni",
      name:      "por_n",
      act:       "rcv",
      partition: "secondary",
    },
    { struct:    "clkmgr_out",
      type:      "uni",
      name:      "sns_clks",
      act:       "rcv",
      package:   "clkmgr_pkg",
      partition: "secondary",
      default:   "'0",
    },
    { struct:    "rstmgr_out",
      type:      "uni",
      name:      "sns_rsts",
      act:       "rcv",
      package:   "rstmgr_pkg",
      partition: "secondary",
      default:   "'0",
    },
    { struct:    "logic",
      type:      "uni",
      name:      "sns_spi_ext_clk",
      act:       "rcv",
      partition: "secondary",
    },
    { struct:    "clks_osc_byp",
      type:      "uni",
      name:      "clk_osc_byp",
      act:       "rcv",
      package:   "ast_pkg",
      partition: "secondary",
    },
    // VCC supply test for OS FPGA
    { struct:    "logic",
      type:      "uni",
      name:      "vcc_supp",
      act:       "rcv",
      partition: "secondary",
    },
    // VCAON Supply Test for OS FPGA
    { struct:    "logic",
      type:      "uni",
      name:      "vcaon_supp",
      act:       "rcv",
      partition: "secondary",
    },
    // VCMAIN Supply Test for OS FPGA
    { struct:    "logic",
      type:      "uni",
      name:      "vcmain_supp",
      act:       "rcv",
      partition: "secondary",
    },
    // VIOA Rail Supply Test for OS FPGA
    { struct:    "logic",
      type:      "uni",
      name:      "vioa_supp",
      act:       "rcv",
      partition: "secondary",
    },
    // VIOB Rail Supply Test for OS FPGA
    { struct:    "logic",
      type:      "uni",
      name:      "viob_supp",
      act:       "rcv",
      partition: "secondary",
    },
    // AON, MAIN, IO-0 Rail, IO-1 Rail Power OK @1.1V
    { struct:    "ast_pwst",
      type:      "uni",
      name:      "ast_pwst",
      act:       "req",
      package:   "ast_pkg",
      partition: "secondary",
    },
    // AON, MAIN, IO-9 Rail, IO-1 Rail Power OK @3.3V
    { struct:    "ast_pwst",
      type:      "uni",
      name:      "ast_pwst_h",
      act:       "req",
      package:   "ast_pkg",
      partition: "secondary",
    },
    // Power handshake with pwrmgr: receives clock enables and main power-down,
    // returns clock valids and main POK. Enables/valids for the sys/io/usb
    // sources are exchanged with the primary partition over the intra-IP structs.
    { struct:    "pwr_ast",
      type:      "req_rsp",
      name:      "pwr_ast",
      act:       "rsp",
      package:   "pwrmgr_pkg",
      partition: "secondary",
    },
    // Power down monitor (flash / OTP)
    { struct:    "logic",
      type:      "uni",
      name:      "flash_power_down_h",
      act:       "req",
      partition: "secondary",
    },
    { struct:    "logic",
      type:      "uni",
      name:      "flash_power_ready_h",
      act:       "req",
      partition: "secondary",
    },
    { struct:    "logic",
      type:      "uni",
      name:      "otp_power_seq",
      width:     "2",
      act:       "rcv",
      partition: "secondary",
    },
    { struct:    "logic",
      type:      "uni",
      name:      "otp_power_seq_h",
      width:     "2",
      act:       "req",
      partition: "secondary",
    },
    // AON source clock
    { struct:    "logic",
      type:      "uni",
      name:      "clk_src_aon", // TODO: is this a clock?
      act:       "req",
      partition: "secondary",
    },
    // USB reference and calibration
    { struct:    "logic",
      type:      "uni",
      name:      "usb_ref_pulse",
      act:       "rcv",
      partition: "secondary",
    },
    { struct:    "logic",
      type:      "uni",
      name:      "usb_ref_val",
      act:       "rcv",
      partition: "secondary",
    },
    { struct:    "logic",
      type:      "uni",
      name:      "usb_io_pu_cal",
      width:     "UsbCalibWidth",
      act:       "req",
      partition: "secondary",
    },
    // ADC digital interface to adc_ctrl
    { struct:    "adc_ast",
      type:      "req_rsp",
      name:      "adc",
      act:       "rsp",
      package:   "ast_pkg",
      partition: "secondary",
    },
    // Analog ADC inputs
    { struct:    "awire",
      type:      "uni",
      name:      "adc_a0",
      act:       "rcv",
      package:   "ast_pkg",
      partition: "secondary",
    },
    { struct:    "awire",
      type:      "uni",
      name:      "adc_a1",
      act:       "rcv",
      package:   "ast_pkg",
      partition: "secondary",
    },
    // Analog alert events to sensor_ctrl.
    { struct:    "ast_alert",
      type:      "req_rsp",
      name:      "ast_alert",
      act:       "req",
      package:   "ast_pkg",
      partition: "secondary",
    },
    // DFT interface
    { struct:    "dft_strap_test_req",
      type:      "uni",
      name:      "dft_strap_test",
      act:       "rcv",
      package:   "pinmux_pkg",
      partition: "secondary",
    },
    { struct:    "lc_tx",
      type:      "uni",
      name:      "lc_dft_en",
      act:       "rcv",
      package:   "lc_ctrl_pkg",
      partition: "secondary",
    },
    { struct:    "logic",
      type:      "uni",
      name:      "fla_obs",
      width:     "8",
      act:       "rcv",
      partition: "secondary",
    },
    { struct:    "logic",
      type:      "uni",
      name:      "otp_obs",
      width:     "8",
      act:       "rcv",
      partition: "secondary",
    },
    { struct:    "logic",
      type:      "uni",
      name:      "otm_obs",
      width:     "8",
      act:       "rcv",
      partition: "secondary",
    },
    { struct:    "logic",
      type:      "uni",
      name:      "usb_obs",
      act:       "rcv",
      partition: "secondary",
    },
    { struct:    "ast_obs_ctrl",
      type:      "uni",
      name:      "obs_ctrl",
      act:       "req",
      package:   "ast_pkg",
      partition: "secondary",
    },
    // Pad mux
    { struct:    "logic",
      type:      "uni",
      name:      "padmux2ast",
      width:     "Pad2AstInWidth",
      act:       "rcv",
      partition: "secondary",
    },
    { struct:    "logic",
      type:      "uni",
      name:      "ast2padmux",
      width:     "Ast2PadOutWidth",
      act:       "req",
      partition: "secondary",
    },
    { struct:    "logic",
      type:      "uni",
      name:      "mux_iob_sel",
      width:     "4",
      act:       "req",
      partition: "secondary",
    },
    // Analog test outputs
    { struct:    "awire",
      type:      "uni",
      name:      "ast2pad_t0",
      act:       "req",
      package:   "ast_pkg",
      partition: "secondary",
    },
    { struct:    "awire",
      type:      "uni",
      name:      "ast2pad_t1",
      act:       "req",
      package:   "ast_pkg",
      partition: "secondary",
    },
    // Flash BIST enable. The clock-bypass requests and ext_freq_is_96m are only
    // consumed by the primary partition; the AON bypass path receives what it
    // needs over the intra-IP structs.
    { struct:    "mubi4",
      type:      "uni",
      name:      "flash_bist_en",
      width:     "1",
      act:       "req",
      package:   "prim_mubi_pkg",
      partition: "secondary",
    },
    // Memory read-write margins, typed as the memory config structs (one
    // margin per memory type). Exposed as top outputs; the chip level
    // broadcasts each to every memory of that type (ram_cfg is a wide,
    // cross-power-domain req_rsp bundle that topgen cannot fan out itself).
    { struct:    "ram_1r1w_cfg_req",
      type:      "uni",
      name:      "tpram_rm",
      act:       "req",
      package:   "prim_ram_1r1w_pkg",
      partition: "secondary",
    },
    { struct:    "ram_1p_cfg_req",
      type:      "uni",
      name:      "spram_rm",
      act:       "req",
      package:   "prim_ram_1p_pkg",
      partition: "secondary",
    },
    { struct:    "rom_cfg_req",
      type:      "uni",
      name:      "sprom_rm",
      act:       "req",
      package:   "prim_rom_pkg",
      partition: "secondary",
    },
    // Scan interface
    { struct:    "mubi4",
      type:      "uni",
      name:      "dft_scan_md",
      width:     "1",
      act:       "req",
      package:   "prim_mubi_pkg",
      partition: "secondary",
    },
    { struct:    "logic",
      type:      "uni",
      name:      "scan_shift_en",
      act:       "req",
      partition: "secondary",
    },
    { struct:    "logic",
      type:      "uni",
      name:      "scan_reset_n",
      act:       "req",
      partition: "secondary",
    },
    // Note: the analog inputs (adc_a0_ai / adc_a1_ai) and the analog pad
    // outputs (ast2pad_t0_ao / ast2pad_t1_ao) connect directly to pads, not to
    // other IPs, so they are intentionally not modelled as inter-module signals.

    //////////////////////
    // Intra-IP signals //
    //////////////////////
    { struct:    "main_to_aon",
      type:      "uni",
      name:      "main_to_aon",
      act:       "req",
      package:   "ast_pkg",
    },
    { struct:    "aon_to_main",
      type:      "uni",
      name:      "aon_to_main",
      act:       "rcv",
      package:   "ast_pkg",
    },
    { struct:    "aon_to_main",
      type:      "uni",
      name:      "aon_to_main",
      act:       "req",
      package:   "ast_pkg",
      partition: "secondary",
    },
    { struct:    "main_to_aon",
      type:      "uni",
      name:      "main_to_aon",
      act:       "rcv",
      package:   "ast_pkg",
      partition: "secondary",
    },
  ],
  regwidth: "32",
  registers: [
    { name: "REGA0",
      desc: "AST Register 0 for OTP/ROM Write Testing",
      swaccess: "ro",
      hwaccess: "hro",
      tags: [ // don't write random data to any of the AST registers
              "excl:CsrAllTests:CsrExclAll" ],
      fields: [
        { bits: "31:0",
          name: "reg32",
          desc: "32-bit Register",
          resval: "0x00",
        },
      ],
    }, //----------------------------------------------------------------------
    { name: "REGA1",
      desc: "AST 1 Register for OTP/ROM Write Testing",
      swaccess: "ro",
      hwaccess: "hro",
      tags: [ // don't write random data to any of the AST registers
              "excl:CsrAllTests:CsrExclAll" ],
      fields: [
        { bits: "31:0",
          name: "reg32",
          desc: "32-bit Register",
          resval: "0x01",
        },
      ],
    }, //----------------------------------------------------------------------
    { name: "REGA2",
      desc: "AST 2 Register for OTP/ROM Write Testing",
      swaccess: "rw",
      hwaccess: "hro",
      tags: [ // don't write random data to any of the AST registers
              "excl:CsrAllTests:CsrExclWrite" ],
      fields: [
        { bits: "31:0",
          name: "reg32",
          desc: "32-bit Register",
          resval: "0x02",
        },
      ],
    }, //----------------------------------------------------------------------
    { name: "REGA3",
      desc: "AST 3 Register for OTP/ROM Write Testing",
      swaccess: "rw",
      hwaccess: "hro",
      tags: [ // don't write random data to any of the AST registers
              "excl:CsrAllTests:CsrExclWrite" ],
      fields: [
        { bits: "31:0",
          name: "reg32",
          desc: "32-bit Register",
          resval: "0x03",
        },
      ],
    }, //----------------------------------------------------------------------
    { name: "REGA4",
      desc: "AST 4 Register for OTP/ROM Write Testing",
      swaccess: "rw",
      hwaccess: "hro",
      tags: [ // don't write random data to any of the AST registers
              "excl:CsrAllTests:CsrExclWrite" ],
      fields: [
        { bits: "31:0",
          name: "reg32",
          desc: "32-bit Register",
          resval: "0x04",
        },
      ],
    }, //----------------------------------------------------------------------
    { name: "REGA5",
      desc: "AST 5 Register for OTP/ROM Write Testing",
      swaccess: "rw",
      hwaccess: "hro",
      tags: [ // don't write random data to any of the AST registers
              "excl:CsrAllTests:CsrExclWrite" ],
      fields: [
        { bits: "31:0",
          name: "reg32",
          desc: "32-bit Register",
          resval: "0x05",
        },
      ],
    }, //----------------------------------------------------------------------
    { name: "REGA6",
      desc: "AST 6 Register for OTP/ROM Write Testing",
      swaccess: "rw",
      hwaccess: "hro",
      tags: [ // don't write random data to any of the AST registers
              "excl:CsrAllTests:CsrExclWrite" ],
      fields: [
        { bits: "31:0",
          name: "reg32",
          desc: "32-bit Register",
          resval: "0x06",
        },
      ],
    }, //----------------------------------------------------------------------
    { name: "REGA7",
      desc: "AST 7 Register for OTP/ROM Write Testing",
      swaccess: "rw",
      hwaccess: "hro",
      tags: [ // don't write random data to any of the AST registers
              "excl:CsrAllTests:CsrExclWrite" ],
      fields: [
        { bits: "31:0",
          name: "reg32",
          desc: "32-bit Register",
          resval: "0x07",
        },
      ],
    }, //----------------------------------------------------------------------
    { name: "REGA8",
      desc: "AST 8 Register for OTP/ROM Write Testing",
      swaccess: "rw",
      hwaccess: "hro",
      tags: [ // don't write random data to any of the AST registers
              "excl:CsrAllTests:CsrExclWrite" ],
      fields: [
        { bits: "31:0",
          name: "reg32",
          desc: "32-bit Register",
          resval: "0x08",
        },
      ],
    }, //----------------------------------------------------------------------
    { name: "REGA9",
      desc: "AST 9 Register for OTP/ROM Write Testing",
      swaccess: "rw",
      hwaccess: "hro",
      tags: [ // don't write random data to any of the AST registers
              "excl:CsrAllTests:CsrExclWrite" ],
      fields: [
        { bits: "31:0",
          name: "reg32",
          desc: "32-bit Register",
          resval: "0x09",
        },
      ],
    }, //----------------------------------------------------------------------
    { name: "REGA10",
      desc: "AST 10 Register for OTP/ROM Write Testing",
      swaccess: "rw",
      hwaccess: "hro",
      tags: [ // don't write random data to any of the AST registers
              "excl:CsrAllTests:CsrExclWrite" ],
      fields: [
        { bits: "31:0",
          name: "reg32",
          desc: "32-bit Register",
          resval: "0x0A",
        },
      ],
    }, //----------------------------------------------------------------------
    { name: "REGA11",
      desc: "AST 11 Register for OTP/ROM Write Testing",
      swaccess: "rw",
      hwaccess: "hro",
      tags: [ // don't write random data to any of the AST registers
              "excl:CsrAllTests:CsrExclWrite" ],
      fields: [
        { bits: "31:0",
          name: "reg32",
          desc: "32-bit Register",
          resval: "0x0B",
        },
      ],
    }, //----------------------------------------------------------------------
    { name: "REGA12",
      desc: "AST 13 Register for OTP/ROM Write Testing",
      swaccess: "rw",
      hwaccess: "hro",
      tags: [ // don't write random data to any of the AST registers
              "excl:CsrAllTests:CsrExclWrite" ],
      fields: [
        { bits: "31:0",
          name: "reg32",
          desc: "32-bit Register",
          resval: "0x0C",
        },
      ],
    }, //----------------------------------------------------------------------
    { name: "REGA13",
      desc: "AST 13 Register for OTP/ROM Write Testing",
      swaccess: "rw",
      hwaccess: "hro",
      tags: [ // don't write random data to any of the AST registers
              "excl:CsrAllTests:CsrExclWrite" ],
      fields: [
        { bits: "31:0",
          name: "reg32",
          desc: "32-bit Register",
          resval: "0x0D",
        },
      ],
    }, //----------------------------------------------------------------------
    { name: "REGA14",
      desc: "AST 14 Register for OTP/ROM Write Testing",
      swaccess: "rw",
      hwaccess: "hro",
      tags: [ // don't write random data to any of the AST registers
              "excl:CsrAllTests:CsrExclWrite" ],
      fields: [
        { bits: "31:0",
          name: "reg32",
          desc: "32-bit Register",
          resval: "0x0E",
        },
      ],
    }, //----------------------------------------------------------------------
    { name: "REGA15",
      desc: "AST 15 Register for OTP/ROM Write Testing",
      swaccess: "rw",
      hwaccess: "hro",
      tags: [ // don't write random data to any of the AST registers
              "excl:CsrAllTests:CsrExclWrite" ],
      fields: [
        { bits: "31:0",
          name: "reg32",
          desc: "32-bit Register",
          resval: "0x0F",
        },
      ],
    }, //----------------------------------------------------------------------
    { name: "REGA16",
      desc: "AST 16 Register for OTP/ROM Write Testing",
      swaccess: "rw",
      hwaccess: "hro",
      tags: [ // don't write random data to any of the AST registers
              "excl:CsrAllTests:CsrExclWrite" ],
      fields: [
        { bits: "31:0",
          name: "reg32",
          desc: "32-bit Register",
          resval: "0x10",
        },
      ],
    }, //----------------------------------------------------------------------
    { name: "REGA17",
      desc: "AST 17 Register for OTP/ROM Write Testing",
      swaccess: "rw",
      hwaccess: "hro",
      tags: [ // don't write random data to any of the AST registers
              "excl:CsrAllTests:CsrExclWrite" ],
      fields: [
        { bits: "31:0",
          name: "reg32",
          desc: "32-bit Register",
          resval: "0x11",
        },
      ],
    }, //----------------------------------------------------------------------
    { name: "REGA18",
      desc: "AST 18 Register for OTP/ROM Write Testing",
      swaccess: "rw",
      hwaccess: "hro",
      tags: [ // don't write random data to any of the AST registers
              "excl:CsrAllTests:CsrExclWrite" ],
      fields: [
        { bits: "31:0",
          name: "reg32",
          desc: "32-bit Register",
          resval: "0x12",
        },
      ],
    }, //----------------------------------------------------------------------
    { name: "REGA19",
      desc: "AST 19 Register for OTP/ROM Write Testing",
      swaccess: "rw",
      hwaccess: "hro",
      tags: [ // don't write random data to any of the AST registers
              "excl:CsrAllTests:CsrExclWrite" ],
      fields: [
        { bits: "31:0",
          name: "reg32",
          desc: "32-bit Register",
          resval: "0x13",
        },
      ],
    }, //----------------------------------------------------------------------
    { name: "REGA20",
      desc: "AST 20 Register for OTP/ROM Write Testing",
      swaccess: "rw",
      hwaccess: "hro",
      tags: [ // don't write random data to any of the AST registers
              "excl:CsrAllTests:CsrExclWrite" ],
      fields: [
        { bits: "31:0",
          name: "reg32",
          desc: "32-bit Register",
          resval: "0x14",
        },
      ],
    }, //----------------------------------------------------------------------
    { name: "REGA21",
      desc: "AST 21 Register for OTP/ROM Write Testing",
      swaccess: "rw",
      hwaccess: "hro",
      tags: [ // don't write random data to any of the AST registers
              "excl:CsrAllTests:CsrExclWrite" ],
      fields: [
        { bits: "31:0",
          name: "reg32",
          desc: "32-bit Register",
          resval: "0x15",
        },
      ],
    }, //----------------------------------------------------------------------
    { name: "REGA22",
      desc: "AST 22 Register for OTP/ROM Write Testing",
      swaccess: "rw",
      hwaccess: "hro",
      tags: [ // don't write random data to any of the AST registers
              "excl:CsrAllTests:CsrExclWrite" ],
      fields: [
        { bits: "31:0",
          name: "reg32",
          desc: "32-bit Register",
          resval: "0x16",
        },
      ],
    }, //----------------------------------------------------------------------
    { name: "REGA23",
      desc: "AST 23 Register for OTP/ROM Write Testing",
      swaccess: "rw",
      hwaccess: "hro",
      tags: [ // don't write random data to any of the AST registers
              "excl:CsrAllTests:CsrExclWrite" ],
      fields: [
        { bits: "31:0",
          name: "reg32",
          desc: "32-bit Register",
          resval: "0x17",
        },
      ],
    }, //----------------------------------------------------------------------
    { name: "REGA24",
      desc: "AST 24 Register for OTP/ROM Write Testing",
      swaccess: "rw",
      hwaccess: "hro",
      tags: [ // don't write random data to any of the AST registers
              "excl:CsrAllTests:CsrExclWrite" ],
      fields: [
        { bits: "31:0",
          name: "reg32",
          desc: "32-bit Register",
          resval: "0x18",
        },
      ],
    }, //----------------------------------------------------------------------
    { name: "REGA25",
      desc: "AST 25 Register for OTP/ROM Write Testing",
      swaccess: "rw",
      hwaccess: "hro",
      tags: [ // don't write random data to any of the AST registers
              "excl:CsrAllTests:CsrExclWrite" ],
      fields: [
        { bits: "31:0",
          name: "reg32",
          desc: "32-bit Register",
          resval: "0x19",
        },
      ],
    }, //----------------------------------------------------------------------
    { name: "REGA26",
      desc: "AST 26 Register for OTP/ROM Write Testing",
      swaccess: "rw",
      hwaccess: "hro",
      tags: [ // don't write random data to any of the AST registers
              "excl:CsrAllTests:CsrExclWrite" ],
      fields: [
        { bits: "31:0",
          name: "reg32",
          desc: "32-bit Register",
          resval: "0x1A",
        },
      ],
    }, //----------------------------------------------------------------------
    { name: "REGA27",
      desc: "AST 27 Register for OTP/ROM Write Testing",
      swaccess: "rw",
      hwaccess: "hro",
      tags: [ // don't write random data to any of the AST registers
              "excl:CsrAllTests:CsrExclWrite" ],
      fields: [
        { bits: "31:0",
          name: "reg32",
          desc: "32-bit Register",
          resval: "0x1B",
        },
      ],
    }, //----------------------------------------------------------------------
    { name: "REGA28",
      desc: "AST 28 Register for OTP/ROM Write Testing",
      swaccess: "ro",
      hwaccess: "hro",
      tags: [ // don't write random data to any of the AST registers
              "excl:CsrAllTests:CsrExclWrite" ],
      fields: [
        { bits: "31:0",
          name: "reg32",
          desc: "32-bit Register",
          resval: "0x1C",
        },
      ],
    }, //----------------------------------------------------------------------
    { name: "REGA29",
      desc: "AST 29 Register for OTP/ROM Write Testing",
      swaccess: "rw",
      hwaccess: "hro",
      tags: [ // don't write random data to any of the AST registers
              "excl:CsrAllTests:CsrExclWrite" ],
      fields: [
        { bits: "31:0",
          name: "reg32",
          desc: "32-bit Register",
          resval: "0x1D",
        },
      ],
    }, //----------------------------------------------------------------------
    { name: "REGA30",
      desc: "AST 30 Register for OTP/ROM Write Testing",
      swaccess: "rw",
      hwaccess: "hro",
      tags: [ // don't write random data to any of the AST registers
              "excl:CsrAllTests:CsrExclWrite" ],
      fields: [
        { bits: "31:0",
          name: "reg32",
          desc: "32-bit Register",
          resval: "0x1E",
        },
      ],
    }, //----------------------------------------------------------------------
    { name: "REGA31",
      desc: "AST 31 Register for OTP/ROM Write Testing",
      swaccess: "rw",
      hwaccess: "hro",
      tags: [ // don't write random data to any of the AST registers
              "excl:CsrAllTests:CsrExclWrite" ],
      fields: [
        { bits: "31:0",
          name: "reg32",
          desc: "32-bit Register",
          resval: "0x1F",
        },
      ],
    }, //----------------------------------------------------------------------
    { name: "REGA32",
      desc: "AST 32 Register for OTP/ROM Write Testing",
      swaccess: "rw",
      hwaccess: "hro",
      tags: [ // don't write random data to any of the AST registers
              "excl:CsrAllTests:CsrExclWrite" ],
      fields: [
        { bits: "31:0",
          name: "reg32",
          desc: "32-bit Register",
          resval: "0x20",
        },
      ],
    }, //----------------------------------------------------------------------
    { name: "REGA33",
      desc: "AST 33 Register for OTP/ROM Write Testing",
      swaccess: "rw",
      hwaccess: "hro",
      tags: [ // don't write random data to any of the AST registers
              "excl:CsrAllTests:CsrExclWrite" ],
      fields: [
        { bits: "31:0",
          name: "reg32",
          desc: "32-bit Register",
          resval: "0x21",
        },
      ],
    }, //----------------------------------------------------------------------
    { name: "REGA34",
      desc: "AST 34 Register for OTP/ROM Write Testing",
      swaccess: "rw",
      hwaccess: "hro",
      tags: [ // don't write random data to any of the AST registers
              "excl:CsrAllTests:CsrExclWrite" ],
      fields: [
        { bits: "31:0",
          name: "reg32",
          desc: "32-bit Register",
          resval: "0x22",
        },
      ],
    }, //----------------------------------------------------------------------
    { name: "REGA35",
      desc: "AST 35 Register for OTP/ROM Write Testing",
      swaccess: "rw",
      hwaccess: "hro",
      tags: [ // don't write random data to any of the AST registers
              "excl:CsrAllTests:CsrExclWrite" ],
      fields: [
        { bits: "31:0",
          name: "reg32",
          desc: "32-bit Register",
          resval: "0x23",
        },
      ],
    }, //----------------------------------------------------------------------
    { name: "REGA36",
      desc: "AST 36 Register for OTP/ROM Write Testing",
      swaccess: "rw",
      hwaccess: "hro",
      tags: [ // don't write random data to any of the AST registers
              "excl:CsrAllTests:CsrExclWrite" ],
      fields: [
        { bits: "31:0",
          name: "reg32",
          desc: "32-bit Register",
          resval: "0x24",
        },
      ],
    }, //----------------------------------------------------------------------
    { name: "REGA37",
      desc: "AST 37 Register for OTP/ROM Write Testing",
      swaccess: "rw",
      hwaccess: "hro",
      tags: [ // don't write random data to any of the AST registers
              "excl:CsrAllTests:CsrExclWrite" ],
      fields: [
        { bits: "31:0",
          name: "reg32",
          desc: "32-bit Register",
          resval: "0x25",
        },
      ],
    }, //----------------------------------------------------------------------
    { name: "REGA38",
      desc: "AST 38 Register for OTP/ROM Write Testing",
      swaccess: "rw",
      hwaccess: "hro",
      tags: [ // don't write random data to any of the AST registers
              "excl:CsrAllTests:CsrExclWrite" ],
      fields: [
        { bits: "31:0",
          name: "reg32",
          desc: "32-bit Register",
          resval: "0x26",
        },
      ],
    }, //----------------------------------------------------------------------
    { name: "REGA39",
      desc: "AST 39 Register for OTP/ROM Write Testing",
      swaccess: "rw",
      hwaccess: "hro",
      tags: [ // don't write random data to any of the AST registers
              "excl:CsrAllTests:CsrExclWrite" ],
      fields: [
        { bits: "31:0",
          name: "reg32",
          desc: "32-bit Register",
          resval: "0x27",
        },
      ],
    }, //----------------------------------------------------------------------
    { name: "REGA40",
      desc: "AST 40 Register for OTP/ROM Write Testing",
      swaccess: "rw",
      hwaccess: "hro",
      tags: [ // don't write random data to any of the AST registers
              "excl:CsrAllTests:CsrExclWrite" ],
      fields: [
        { bits: "31:0",
          name: "reg32",
          desc: "32-bit Register",
          resval: "0x28",
        },
      ],
    }, //----------------------------------------------------------------------
    { name: "REGA41",
      desc: "AST 41 Register for OTP/ROM Write Testing",
      swaccess: "rw",
      hwaccess: "hro",
      tags: [ // don't write random data to any of the AST registers
              "excl:CsrAllTests:CsrExclWrite" ],
      fields: [
        { bits: "31:0",
          name: "reg32",
          desc: "32-bit Register",
          resval: "0x29",
        },
      ],
    }, //----------------------------------------------------------------------
    { name: "REGA42",
      desc: "AST 42 Register for OTP/ROM Write Testing",
      swaccess: "rw",
      hwaccess: "hro",
      tags: [ // don't write random data to any of the AST registers
              "excl:CsrAllTests:CsrExclWrite" ],
      fields: [
        { bits: "31:0",
          name: "reg32",
          desc: "32-bit Register",
          resval: "0x2a",
        },
      ],
    }, //----------------------------------------------------------------------
    { name: "REGA43",
      desc: "AST 43 Register for OTP/ROM Write Testing",
      swaccess: "rw",
      hwaccess: "hro",
      tags: [ // don't write random data to any of the AST registers
              "excl:CsrAllTests:CsrExclWrite" ],
      fields: [
        { bits: "31:0",
          name: "reg32",
          desc: "32-bit Register",
          resval: "0x2b",
        },
      ],
    }, //----------------------------------------------------------------------
    { name: "REGA44",
      desc: "AST 44 Register for OTP/ROM Write Testing",
      swaccess: "rw",
      hwaccess: "hro",
      tags: [ // don't write random data to any of the AST registers
              "excl:CsrAllTests:CsrExclWrite" ],
      fields: [
        { bits: "31:0",
          name: "reg32",
          desc: "32-bit Register",
          resval: "0x2c",
        },
      ],
    }, //----------------------------------------------------------------------
    { name: "REGA45",
      desc: "AST 45 Register for OTP/ROM Write Testing",
      swaccess: "rw",
      hwaccess: "hro",
      tags: [ // don't write random data to any of the AST registers
              "excl:CsrAllTests:CsrExclWrite" ],
      fields: [
        { bits: "31:0",
          name: "reg32",
          desc: "32-bit Register",
          resval: "0x2d",
        },
      ],
    }, //----------------------------------------------------------------------
    { name: "REGA46",
      desc: "AST 46 Register for OTP/ROM Write Testing",
      swaccess: "rw",
      hwaccess: "hro",
      tags: [ // don't write random data to any of the AST registers
              "excl:CsrAllTests:CsrExclWrite" ],
      fields: [
        { bits: "31:0",
          name: "reg32",
          desc: "32-bit Register",
          resval: "0x2e",
        },
      ],
    }, //----------------------------------------------------------------------
    { name: "REGA47",
      desc: "AST 47 Register for OTP/ROM Write Testing",
      swaccess: "rw",
      hwaccess: "hro",
      tags: [ // don't write random data to any of the AST registers
              "excl:CsrAllTests:CsrExclWrite" ],
      fields: [
        { bits: "31:0",
          name: "reg32",
          desc: "32-bit Register",
          resval: "0x2f",
        },
      ],
    }, //----------------------------------------------------------------------
    { name: "REGA48",
      desc: "AST 48 Register for OTP/ROM Write Testing",
      swaccess: "rw",
      hwaccess: "hro",
      tags: [ // don't write random data to any of the AST registers
              "excl:CsrAllTests:CsrExclWrite" ],
      fields: [
        { bits: "31:0",
          name: "reg32",
          desc: "32-bit Register",
          resval: "0x30",
        },
      ],
    }, //----------------------------------------------------------------------
    { name: "REGA49",
      desc: "AST 49 Register for OTP/ROM Write Testing",
      swaccess: "rw",
      hwaccess: "hro",
      tags: [ // don't write random data to any of the AST registers
              "excl:CsrAllTests:CsrExclWrite" ],
      fields: [
        { bits: "31:0",
          name: "reg32",
          desc: "32-bit Register",
          resval: "0x31",
        },
      ],
    }, //----------------------------------------------------------------------
    { name: "REGA50",
      desc: "AST 50 Register for OTP/ROM Write Testing",
      swaccess: "rw",
      hwaccess: "hro",
      tags: [ // don't write random data to any of the AST registers
              "excl:CsrAllTests:CsrExclWrite" ],
      fields: [
        { bits: "31:0",
          name: "reg32",
          desc: "32-bit Register",
          resval: "0x32",
        },
      ],
    }, //----------------------------------------------------------------------
    { name: "REGA51",
      desc: "AST 51 Register for OTP/ROM Write Testing",
      swaccess: "rw",
      hwaccess: "hro",
      tags: [ // don't write random data to any of the AST registers
              "excl:CsrAllTests:CsrExclWrite" ],
      fields: [
        { bits: "31:0",
          name: "reg32",
          desc: "32-bit Register",
          resval: "0x33",
        },
      ],
    }, //----------------------------------------------------------------------
    { name: "REGA52",
      desc: "AST 52 Register for OTP/ROM Write Testing",
      swaccess: "rw",
      hwaccess: "hro",
      tags: [ // don't write random data to any of the AST registers
              "excl:CsrAllTests:CsrExclWrite" ],
      fields: [
        { bits: "31:0",
          name: "reg32",
          desc: "32-bit Register",
          resval: "0x34",
        },
      ],
    }, //----------------------------------------------------------------------
    { name: "REGAL",
      desc: "AST Last Register for OTP/ROM Write Testing",
      swaccess: "wo",
      hwaccess: "hrw",
      hwext:    "true",
      hwqe:     "true",
      tags: [ // don't write random data to any of the AST registers
              "excl:CsrAllTests:CsrExclAll" ],
      fields: [
        { bits: "31:0",
          name: "reg32",
          desc: "32-bit Register",
          resval: "0x35",
        },
      ],
    }, //----------------------------------------------------------------------
    ///////////////////////////////////////////////////////////////////////////
    { skipto: "0x200" }
    ///////////////////////////////////////////////////////////////////////////
    { multireg:
      {
        name: "REGB",
        desc: "AST Registers Array-B to set address space size",
        count: "NumRegsB",
        cname: "REGB",
        swaccess: "rw",
        hwaccess: "hro",
        tags: [ // don't write random data to any of the AST registers
                "excl:CsrAllTests:CsrExclAll" ],
        fields: [
          { bits: "31:0",
            name: "reg32",
            desc: "32-bit Register",
            resval: "0",
          },
        ],
      },
    }, //----------------------------------------------------------------------
  ],
}
