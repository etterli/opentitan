// Copyright lowRISC contributors (OpenTitan project).
// Licensed under the Apache License, Version 2.0, see LICENSE for details.
// SPDX-License-Identifier: Apache-2.0
//#############################################################################
// *Name: ast
// *Module Description: Analog Sensors Top Registers
//#############################################################################
{ name:               "ast",
  // Unique comportable IP identifier defined under KNOWN_CIP_IDS in the regtool.
  cip_id:             "34",
  design_spec:        "../doc",
  dv_doc:             "",
  hw_checklist:       "",
  sw_checklist:       "",
  version:            "2.0.0",
  life_stage:         "L1",
  design_stage:       "D1",
  verification_stage: "V2S",
  dif_stage:          "",
  clocking: {
    primary: [
    { clock: "clk_ast_tlul_i",  reset: "rst_ast_tlul_ni", primary: true },
    { clock: "clk_ast_es_i",    reset: "rst_ast_es_ni"},
    { clock: "clk_ast_usb_i",   reset: "rst_ast_usb_ni"},
    ],
    secondary: [
    { clock: "clk_ast_adc_i",   reset: "rst_ast_adc_ni"},
    // Primary clock because it controls alerts.
    { clock: "clk_ast_alert_i", reset: "rst_ast_alert_ni", primary: true},
    { clock: "clk_ast_es_i",    reset: "rst_ast_es_ni"},
    { clock: "clk_ast_rng_i",   reset: "rst_ast_rng_ni"},
    { clock: "clk_ast_tlul_i",  reset: "rst_ast_tlul_ni" },
    { clock: "clk_ast_usb_i",   reset: "rst_ast_usb_ni"},
    ],
  },
  bus_interfaces: [
    { protocol: "tlul",
      direction: "device"
    }
  ],
  no_auto_alert_regs: "True",
  param_list: [
    { name:    "NumRegsB",
      desc: "Number of registers in the Array-B",
      type:    "int",
      default: "5",
      local:   "true",
    },
    { name: "NumUsbBeaconPulses",
      desc: "Number of USB valid beacon pulses for clock to re-calibrate",
      type: "int",
      default: "8",
      local: "true"
    },
    // TODO: do we need more parameters here? Can the remaining stay in ast_pkg.sv?
  ],
  // interrupt_list: [],
  alert_list: [
    { name: "as",
      desc: "Active shield alert",
      partition: "secondary",
    },
    { name: "cg",
      desc: "Clock glitch alert",
      partition: "secondary",
    },
    { name: "gd",
      desc: "Glitch detector alert",
      partition: "secondary",
    },
    { name: "ts_hi",
      desc: "Temperature sensor high alert",
      partition: "secondary",
    },
    { name: "ts_lo",
      desc: "Temperature sensor low alert",
      partition: "secondary",
    },
    { name: "ot0",
      desc: "Other-0 alert",
      partition: "secondary",
    },
    { name: "ot1",
      desc: "Other-1 alert",
      partition: "secondary",
    },
    { name: "ot2",
      desc: "Other-2 alert",
      partition: "secondary",
    },
    { name: "ot3",
      desc: "Other-3 alert",
      partition: "secondary",
    },
    { name: "ot4",
      desc: "Other-4 alert",
      partition: "secondary",
    },
    { name: "ot5",
      desc: "Other-5 alert",
      partition: "secondary",
    },
  ],
  inter_signal_list: [
    ///////////////////////
    // Primary partition //
    ///////////////////////
    // AST (registers) init done
    { struct:  "mubi4",
      type:    "uni",
      name:    "ast_init_done",
      width:   "1",
      act:     "req",
      package: "prim_mubi_pkg",
    },
    // RNG interface
    { struct:  "logic",
      type:    "uni",
      name:    "rng_en",
      act:     "rcv",
    },
    { struct:  "logic",
      type:    "uni",
      name:    "rng_fips",
      act:     "rcv",
    },
    { struct:  "logic",
      type:    "uni",
      name:    "rng_val",
      act:     "req",
    },
    { struct:  "logic", // TODO: is an array of [ast_pkg::EntropyStreams-1:0]
      type:    "uni",
      name:    "rng_b",
      act:     "req",
    },
    // Entropy interface
    { struct:  "edn",
      type:    "req_rsp",
      name:    "entropy",
      act:     "req",
      package: "edn_pkg",
    },
    // Clock source system jitter enable
    { struct:  "mubi4",
      type:    "uni",
      name:    "clk_src_sys_jen",
      width:   "1",
      act:     "rcv",
      package: "prim_mubi_pkg",
    },
    // Clock bypass interface
    // External clock
    { struct:  "logic",
      type:    "uni",
      name:    "clk_ast_ext",
      act:     "rcv",
    },
    // Clock source system enable
    { struct: "logic",
      type:    "uni",
      name:    "clk_src_sys_en",
      act:     "rcv",
    },
    // Clock source IO enable
    { struct: "logic",
      type:    "uni",
      name:    "clk_src_io_en",
      act:     "rcv",
    },
    // Clock source USB enable
    { struct: "logic",
      type:    "uni",
      name:    "clk_src_usb_en",
      act:     "rcv",
    },
    // Buffered AST USB clock - TODO: is a clock?
    // Buffered AST USB reset - TODO: is a reset? Otherwise _ni not possible.
    // IO clock bypass request
    { struct:  "mubi4",
      type:    "uni",
      name:    "io_clk_byp_req",
      width:   "1",
      act:     "rcv",
      package: "prim_mubi_pkg",
    },
    // All clock bypass request
    { struct:  "mubi4",
      type:    "uni",
      name:    "all_clk_byp_req",
      width:   "1",
      act:     "rcv",
      package: "prim_mubi_pkg",
    },
    // Ext. frequency is 96MHz
    { struct:  "mubi4",
      type:    "uni",
      name:    "ext_freq_is_96m",
      width:   "1",
      act:     "rcv",
      package: "prim_mubi_pkg",
    },
    // TODO: clk_osc_byp_i
    // Clock source system
    { struct: "logic",
      type:    "uni",
      name:    "clk_src_sys",
      act:     "req",
    },
    // Clock source system value
    { struct: "logic",
      type:    "uni",
      name:    "clk_src_sys_val",
      act:     "req",
    },
    // Clock source IO
    { struct: "logic",
      type:    "uni",
      name:    "clk_src_io",
      act:     "req",
    },
    // Clock source IO value
    { struct: "logic",
      type:    "uni",
      name:    "clk_src_io_val",
      act:     "req",
    },
    // Clock source IO 48MHz
    { struct:  "mubi4",
      type:    "uni",
      name:    "clk_src_io_48m",
      width:   "1",
      act:     "req",
      package: "prim_mubi_pkg",
    },
    // Clock source USB
    { struct: "logic",
      type:    "uni",
      name:    "clk_src_usb",
      act:     "req",
    },
    // Clock source USB value
    { struct: "logic",
      type:    "uni",
      name:    "clk_src_usb_val",
      act:     "req",
    },
    // IO clock bypass value ack
    { struct:  "mubi4",
      type:    "uni",
      name:    "io_clk_byp_val_ack",
      width:   "1",
      act:     "req",
      package: "prim_mubi_pkg",
    },
    // All clock bypass value ack
    { struct:  "mubi4",
      type:    "uni",
      name:    "all_clk_byp_val_ack",
      width:   "1",
      act:     "req",
      package: "prim_mubi_pkg",
    },
    /////////////////////////
    // Secondary partition //
    /////////////////////////
    // External clock
    { struct:    "logic",
      type:      "uni",
      name:      "clk_ast_ext",
      act:       "rcv",
      partition: "secondary",
    },
    // TODO: por_ni -> reset?
    { struct:   "clkmgr_out",
      type:      "uni",
      name:      "sns_clks",
      act:       "rcv",
      package:   "clkmgr_pkg",
      partition: "secondary",
    },
    { struct:   "rstmgr_out",
      type:      "uni",
      name:      "sns_rsts",
      act:       "rcv",
      package:   "rstmgr_pkg",
      partition: "secondary",
    },
    { struct:    "logic",
      type:      "uni",
      name:      "sns_spi_ext_clk",
      act:       "rcv",
      partition: "secondary",
    },
    // TODO: clk_osc_byp
    // VCC supply test for OS FPGA
    { struct:    "logic",
      type:      "uni",
      name:      "vcc_supp",
      act:       "rcv",
      partition: "secondary",
    },
    // VCAON Supply Test for OS FPGA
    { struct:    "logic",
      type:      "uni",
      name:      "vcaon_supp_i",
      act:       "rcv",
      partition: "secondary",
    },
    // VCMAIN Supply Test for OS FPGA
    { struct:    "logic",
      type:      "uni",
      name:      "vcmain_supp_i",
      act:       "rcv",
      partition: "secondary",
    },
    // VIOA Rail Supply Test for OS FPGA
    { struct:    "logic",
      type:      "uni",
      name:      "vioa_supp_i",
      act:       "rcv",
      partition: "secondary",
    },
    // VIOB Rail Supply Test for OS FPGA
    { struct:    "logic",
      type:      "uni",
      name:      "viob_supp_i",
      act:       "rcv",
      partition: "secondary",
    },
    // AON, MAIN, IO-0 Rail, IO-1 Rail Power OK @1.1V
    { struct:   "ast_pwst",
      type:      "uni",
      name:      "ast_pwst",
      act:       "rcv",
      package:   "ast_pkg",
      partition: "secondary",
    },
    // AON, MAIN, IO-9 Rail, IO-1 Rail Power OK @3.3V
    { struct:   "ast_pwst",
      type:      "uni",
      name:      "ast_pwst_h",
      act:       "rcv",
      package:   "ast_pkg",
      partition: "secondary",
    },
    // MAIN regulator power down
    { struct:    "logic",
      type:      "uni",
      name:      "main_pd_n", // TODO: is main_pd_ni
      act:       "rcv",
      partition: "secondary",
    },
    // Enveloped ISOlation ENable for MAIN
    { struct:    "logic",
      type:      "uni",
      name:      "main_env_iso_en",
      act:       "rcv",
      partition: "secondary",
    },

// todo finish list.

    //////////////////////
    // Intra-IP signals //
    //////////////////////
    // TODO
  ],
  regwidth: "32",
  registers: [
    { name: "REGA0",
      desc: "AST Register 0 for OTP/ROM Write Testing",
      swaccess: "ro",
      hwaccess: "hro",
      tags: [ // don't write random data to any of the AST registers
              "excl:CsrAllTests:CsrExclAll" ],
      fields: [
        { bits: "31:0",
          name: "reg32",
          desc: "32-bit Register",
          resval: "0x00",
        },
      ],
    }, //----------------------------------------------------------------------
    { name: "REGA1",
      desc: "AST 1 Register for OTP/ROM Write Testing",
      swaccess: "ro",
      hwaccess: "hro",
      tags: [ // don't write random data to any of the AST registers
              "excl:CsrAllTests:CsrExclAll" ],
      fields: [
        { bits: "31:0",
          name: "reg32",
          desc: "32-bit Register",
          resval: "0x01",
        },
      ],
    }, //----------------------------------------------------------------------
    { name: "REGA2",
      desc: "AST 2 Register for OTP/ROM Write Testing",
      swaccess: "rw",
      hwaccess: "hro",
      tags: [ // don't write random data to any of the AST registers
              "excl:CsrAllTests:CsrExclWrite" ],
      fields: [
        { bits: "31:0",
          name: "reg32",
          desc: "32-bit Register",
          resval: "0x02",
        },
      ],
    }, //----------------------------------------------------------------------
    { name: "REGA3",
      desc: "AST 3 Register for OTP/ROM Write Testing",
      swaccess: "rw",
      hwaccess: "hro",
      tags: [ // don't write random data to any of the AST registers
              "excl:CsrAllTests:CsrExclWrite" ],
      fields: [
        { bits: "31:0",
          name: "reg32",
          desc: "32-bit Register",
          resval: "0x03",
        },
      ],
    }, //----------------------------------------------------------------------
    { name: "REGA4",
      desc: "AST 4 Register for OTP/ROM Write Testing",
      swaccess: "rw",
      hwaccess: "hro",
      tags: [ // don't write random data to any of the AST registers
              "excl:CsrAllTests:CsrExclWrite" ],
      fields: [
        { bits: "31:0",
          name: "reg32",
          desc: "32-bit Register",
          resval: "0x04",
        },
      ],
    }, //----------------------------------------------------------------------
    { name: "REGA5",
      desc: "AST 5 Register for OTP/ROM Write Testing",
      swaccess: "rw",
      hwaccess: "hro",
      tags: [ // don't write random data to any of the AST registers
              "excl:CsrAllTests:CsrExclWrite" ],
      fields: [
        { bits: "31:0",
          name: "reg32",
          desc: "32-bit Register",
          resval: "0x05",
        },
      ],
    }, //----------------------------------------------------------------------
    { name: "REGA6",
      desc: "AST 6 Register for OTP/ROM Write Testing",
      swaccess: "rw",
      hwaccess: "hro",
      tags: [ // don't write random data to any of the AST registers
              "excl:CsrAllTests:CsrExclWrite" ],
      fields: [
        { bits: "31:0",
          name: "reg32",
          desc: "32-bit Register",
          resval: "0x06",
        },
      ],
    }, //----------------------------------------------------------------------
    { name: "REGA7",
      desc: "AST 7 Register for OTP/ROM Write Testing",
      swaccess: "rw",
      hwaccess: "hro",
      tags: [ // don't write random data to any of the AST registers
              "excl:CsrAllTests:CsrExclWrite" ],
      fields: [
        { bits: "31:0",
          name: "reg32",
          desc: "32-bit Register",
          resval: "0x07",
        },
      ],
    }, //----------------------------------------------------------------------
    { name: "REGA8",
      desc: "AST 8 Register for OTP/ROM Write Testing",
      swaccess: "rw",
      hwaccess: "hro",
      tags: [ // don't write random data to any of the AST registers
              "excl:CsrAllTests:CsrExclWrite" ],
      fields: [
        { bits: "31:0",
          name: "reg32",
          desc: "32-bit Register",
          resval: "0x08",
        },
      ],
    }, //----------------------------------------------------------------------
    { name: "REGA9",
      desc: "AST 9 Register for OTP/ROM Write Testing",
      swaccess: "rw",
      hwaccess: "hro",
      tags: [ // don't write random data to any of the AST registers
              "excl:CsrAllTests:CsrExclWrite" ],
      fields: [
        { bits: "31:0",
          name: "reg32",
          desc: "32-bit Register",
          resval: "0x09",
        },
      ],
    }, //----------------------------------------------------------------------
    { name: "REGA10",
      desc: "AST 10 Register for OTP/ROM Write Testing",
      swaccess: "rw",
      hwaccess: "hro",
      tags: [ // don't write random data to any of the AST registers
              "excl:CsrAllTests:CsrExclWrite" ],
      fields: [
        { bits: "31:0",
          name: "reg32",
          desc: "32-bit Register",
          resval: "0x0A",
        },
      ],
    }, //----------------------------------------------------------------------
    { name: "REGA11",
      desc: "AST 11 Register for OTP/ROM Write Testing",
      swaccess: "rw",
      hwaccess: "hro",
      tags: [ // don't write random data to any of the AST registers
              "excl:CsrAllTests:CsrExclWrite" ],
      fields: [
        { bits: "31:0",
          name: "reg32",
          desc: "32-bit Register",
          resval: "0x0B",
        },
      ],
    }, //----------------------------------------------------------------------
    { name: "REGA12",
      desc: "AST 13 Register for OTP/ROM Write Testing",
      swaccess: "rw",
      hwaccess: "hro",
      tags: [ // don't write random data to any of the AST registers
              "excl:CsrAllTests:CsrExclWrite" ],
      fields: [
        { bits: "31:0",
          name: "reg32",
          desc: "32-bit Register",
          resval: "0x0C",
        },
      ],
    }, //----------------------------------------------------------------------
    { name: "REGA13",
      desc: "AST 13 Register for OTP/ROM Write Testing",
      swaccess: "rw",
      hwaccess: "hro",
      tags: [ // don't write random data to any of the AST registers
              "excl:CsrAllTests:CsrExclWrite" ],
      fields: [
        { bits: "31:0",
          name: "reg32",
          desc: "32-bit Register",
          resval: "0x0D",
        },
      ],
    }, //----------------------------------------------------------------------
    { name: "REGA14",
      desc: "AST 14 Register for OTP/ROM Write Testing",
      swaccess: "rw",
      hwaccess: "hro",
      tags: [ // don't write random data to any of the AST registers
              "excl:CsrAllTests:CsrExclWrite" ],
      fields: [
        { bits: "31:0",
          name: "reg32",
          desc: "32-bit Register",
          resval: "0x0E",
        },
      ],
    }, //----------------------------------------------------------------------
    { name: "REGA15",
      desc: "AST 15 Register for OTP/ROM Write Testing",
      swaccess: "rw",
      hwaccess: "hro",
      tags: [ // don't write random data to any of the AST registers
              "excl:CsrAllTests:CsrExclWrite" ],
      fields: [
        { bits: "31:0",
          name: "reg32",
          desc: "32-bit Register",
          resval: "0x0F",
        },
      ],
    }, //----------------------------------------------------------------------
    { name: "REGA16",
      desc: "AST 16 Register for OTP/ROM Write Testing",
      swaccess: "rw",
      hwaccess: "hro",
      tags: [ // don't write random data to any of the AST registers
              "excl:CsrAllTests:CsrExclWrite" ],
      fields: [
        { bits: "31:0",
          name: "reg32",
          desc: "32-bit Register",
          resval: "0x10",
        },
      ],
    }, //----------------------------------------------------------------------
    { name: "REGA17",
      desc: "AST 17 Register for OTP/ROM Write Testing",
      swaccess: "rw",
      hwaccess: "hro",
      tags: [ // don't write random data to any of the AST registers
              "excl:CsrAllTests:CsrExclWrite" ],
      fields: [
        { bits: "31:0",
          name: "reg32",
          desc: "32-bit Register",
          resval: "0x11",
        },
      ],
    }, //----------------------------------------------------------------------
    { name: "REGA18",
      desc: "AST 18 Register for OTP/ROM Write Testing",
      swaccess: "rw",
      hwaccess: "hro",
      tags: [ // don't write random data to any of the AST registers
              "excl:CsrAllTests:CsrExclWrite" ],
      fields: [
        { bits: "31:0",
          name: "reg32",
          desc: "32-bit Register",
          resval: "0x12",
        },
      ],
    }, //----------------------------------------------------------------------
    { name: "REGA19",
      desc: "AST 19 Register for OTP/ROM Write Testing",
      swaccess: "rw",
      hwaccess: "hro",
      tags: [ // don't write random data to any of the AST registers
              "excl:CsrAllTests:CsrExclWrite" ],
      fields: [
        { bits: "31:0",
          name: "reg32",
          desc: "32-bit Register",
          resval: "0x13",
        },
      ],
    }, //----------------------------------------------------------------------
    { name: "REGA20",
      desc: "AST 20 Register for OTP/ROM Write Testing",
      swaccess: "rw",
      hwaccess: "hro",
      tags: [ // don't write random data to any of the AST registers
              "excl:CsrAllTests:CsrExclWrite" ],
      fields: [
        { bits: "31:0",
          name: "reg32",
          desc: "32-bit Register",
          resval: "0x14",
        },
      ],
    }, //----------------------------------------------------------------------
    { name: "REGA21",
      desc: "AST 21 Register for OTP/ROM Write Testing",
      swaccess: "rw",
      hwaccess: "hro",
      tags: [ // don't write random data to any of the AST registers
              "excl:CsrAllTests:CsrExclWrite" ],
      fields: [
        { bits: "31:0",
          name: "reg32",
          desc: "32-bit Register",
          resval: "0x15",
        },
      ],
    }, //----------------------------------------------------------------------
    { name: "REGA22",
      desc: "AST 22 Register for OTP/ROM Write Testing",
      swaccess: "rw",
      hwaccess: "hro",
      tags: [ // don't write random data to any of the AST registers
              "excl:CsrAllTests:CsrExclWrite" ],
      fields: [
        { bits: "31:0",
          name: "reg32",
          desc: "32-bit Register",
          resval: "0x16",
        },
      ],
    }, //----------------------------------------------------------------------
    { name: "REGA23",
      desc: "AST 23 Register for OTP/ROM Write Testing",
      swaccess: "rw",
      hwaccess: "hro",
      tags: [ // don't write random data to any of the AST registers
              "excl:CsrAllTests:CsrExclWrite" ],
      fields: [
        { bits: "31:0",
          name: "reg32",
          desc: "32-bit Register",
          resval: "0x17",
        },
      ],
    }, //----------------------------------------------------------------------
    { name: "REGA24",
      desc: "AST 24 Register for OTP/ROM Write Testing",
      swaccess: "rw",
      hwaccess: "hro",
      tags: [ // don't write random data to any of the AST registers
              "excl:CsrAllTests:CsrExclWrite" ],
      fields: [
        { bits: "31:0",
          name: "reg32",
          desc: "32-bit Register",
          resval: "0x18",
        },
      ],
    }, //----------------------------------------------------------------------
    { name: "REGA25",
      desc: "AST 25 Register for OTP/ROM Write Testing",
      swaccess: "rw",
      hwaccess: "hro",
      tags: [ // don't write random data to any of the AST registers
              "excl:CsrAllTests:CsrExclWrite" ],
      fields: [
        { bits: "31:0",
          name: "reg32",
          desc: "32-bit Register",
          resval: "0x19",
        },
      ],
    }, //----------------------------------------------------------------------
    { name: "REGA26",
      desc: "AST 26 Register for OTP/ROM Write Testing",
      swaccess: "rw",
      hwaccess: "hro",
      tags: [ // don't write random data to any of the AST registers
              "excl:CsrAllTests:CsrExclWrite" ],
      fields: [
        { bits: "31:0",
          name: "reg32",
          desc: "32-bit Register",
          resval: "0x1A",
        },
      ],
    }, //----------------------------------------------------------------------
    { name: "REGA27",
      desc: "AST 27 Register for OTP/ROM Write Testing",
      swaccess: "rw",
      hwaccess: "hro",
      tags: [ // don't write random data to any of the AST registers
              "excl:CsrAllTests:CsrExclWrite" ],
      fields: [
        { bits: "31:0",
          name: "reg32",
          desc: "32-bit Register",
          resval: "0x1B",
        },
      ],
    }, //----------------------------------------------------------------------
    { name: "REGA28",
      desc: "AST 28 Register for OTP/ROM Write Testing",
      swaccess: "ro",
      hwaccess: "hro",
      tags: [ // don't write random data to any of the AST registers
              "excl:CsrAllTests:CsrExclWrite" ],
      fields: [
        { bits: "31:0",
          name: "reg32",
          desc: "32-bit Register",
          resval: "0x1C",
        },
      ],
    }, //----------------------------------------------------------------------
    { name: "REGA29",
      desc: "AST 29 Register for OTP/ROM Write Testing",
      swaccess: "rw",
      hwaccess: "hro",
      tags: [ // don't write random data to any of the AST registers
              "excl:CsrAllTests:CsrExclWrite" ],
      fields: [
        { bits: "31:0",
          name: "reg32",
          desc: "32-bit Register",
          resval: "0x1D",
        },
      ],
    }, //----------------------------------------------------------------------
    { name: "REGA30",
      desc: "AST 30 Register for OTP/ROM Write Testing",
      swaccess: "rw",
      hwaccess: "hro",
      tags: [ // don't write random data to any of the AST registers
              "excl:CsrAllTests:CsrExclWrite" ],
      fields: [
        { bits: "31:0",
          name: "reg32",
          desc: "32-bit Register",
          resval: "0x1E",
        },
      ],
    }, //----------------------------------------------------------------------
    { name: "REGA31",
      desc: "AST 31 Register for OTP/ROM Write Testing",
      swaccess: "rw",
      hwaccess: "hro",
      tags: [ // don't write random data to any of the AST registers
              "excl:CsrAllTests:CsrExclWrite" ],
      fields: [
        { bits: "31:0",
          name: "reg32",
          desc: "32-bit Register",
          resval: "0x1F",
        },
      ],
    }, //----------------------------------------------------------------------
    { name: "REGA32",
      desc: "AST 32 Register for OTP/ROM Write Testing",
      swaccess: "rw",
      hwaccess: "hro",
      tags: [ // don't write random data to any of the AST registers
              "excl:CsrAllTests:CsrExclWrite" ],
      fields: [
        { bits: "31:0",
          name: "reg32",
          desc: "32-bit Register",
          resval: "0x20",
        },
      ],
    }, //----------------------------------------------------------------------
    { name: "REGA33",
      desc: "AST 33 Register for OTP/ROM Write Testing",
      swaccess: "rw",
      hwaccess: "hro",
      tags: [ // don't write random data to any of the AST registers
              "excl:CsrAllTests:CsrExclWrite" ],
      fields: [
        { bits: "31:0",
          name: "reg32",
          desc: "32-bit Register",
          resval: "0x21",
        },
      ],
    }, //----------------------------------------------------------------------
    { name: "REGA34",
      desc: "AST 34 Register for OTP/ROM Write Testing",
      swaccess: "rw",
      hwaccess: "hro",
      tags: [ // don't write random data to any of the AST registers
              "excl:CsrAllTests:CsrExclWrite" ],
      fields: [
        { bits: "31:0",
          name: "reg32",
          desc: "32-bit Register",
          resval: "0x22",
        },
      ],
    }, //----------------------------------------------------------------------
    { name: "REGA35",
      desc: "AST 35 Register for OTP/ROM Write Testing",
      swaccess: "rw",
      hwaccess: "hro",
      tags: [ // don't write random data to any of the AST registers
              "excl:CsrAllTests:CsrExclWrite" ],
      fields: [
        { bits: "31:0",
          name: "reg32",
          desc: "32-bit Register",
          resval: "0x23",
        },
      ],
    }, //----------------------------------------------------------------------
    { name: "REGA36",
      desc: "AST 36 Register for OTP/ROM Write Testing",
      swaccess: "rw",
      hwaccess: "hro",
      tags: [ // don't write random data to any of the AST registers
              "excl:CsrAllTests:CsrExclWrite" ],
      fields: [
        { bits: "31:0",
          name: "reg32",
          desc: "32-bit Register",
          resval: "0x24",
        },
      ],
    }, //----------------------------------------------------------------------
    { name: "REGA37",
      desc: "AST 37 Register for OTP/ROM Write Testing",
      swaccess: "rw",
      hwaccess: "hro",
      tags: [ // don't write random data to any of the AST registers
              "excl:CsrAllTests:CsrExclWrite" ],
      fields: [
        { bits: "31:0",
          name: "reg32",
          desc: "32-bit Register",
          resval: "0x25",
        },
      ],
    }, //----------------------------------------------------------------------
    { name: "REGA38",
      desc: "AST 38 Register for OTP/ROM Write Testing",
      swaccess: "rw",
      hwaccess: "hro",
      tags: [ // don't write random data to any of the AST registers
              "excl:CsrAllTests:CsrExclWrite" ],
      fields: [
        { bits: "31:0",
          name: "reg32",
          desc: "32-bit Register",
          resval: "0x26",
        },
      ],
    }, //----------------------------------------------------------------------
    { name: "REGA39",
      desc: "AST 39 Register for OTP/ROM Write Testing",
      swaccess: "rw",
      hwaccess: "hro",
      tags: [ // don't write random data to any of the AST registers
              "excl:CsrAllTests:CsrExclWrite" ],
      fields: [
        { bits: "31:0",
          name: "reg32",
          desc: "32-bit Register",
          resval: "0x27",
        },
      ],
    }, //----------------------------------------------------------------------
    { name: "REGA40",
      desc: "AST 40 Register for OTP/ROM Write Testing",
      swaccess: "rw",
      hwaccess: "hro",
      tags: [ // don't write random data to any of the AST registers
              "excl:CsrAllTests:CsrExclWrite" ],
      fields: [
        { bits: "31:0",
          name: "reg32",
          desc: "32-bit Register",
          resval: "0x28",
        },
      ],
    }, //----------------------------------------------------------------------
    { name: "REGA41",
      desc: "AST 41 Register for OTP/ROM Write Testing",
      swaccess: "rw",
      hwaccess: "hro",
      tags: [ // don't write random data to any of the AST registers
              "excl:CsrAllTests:CsrExclWrite" ],
      fields: [
        { bits: "31:0",
          name: "reg32",
          desc: "32-bit Register",
          resval: "0x29",
        },
      ],
    }, //----------------------------------------------------------------------
    { name: "REGA42",
      desc: "AST 42 Register for OTP/ROM Write Testing",
      swaccess: "rw",
      hwaccess: "hro",
      tags: [ // don't write random data to any of the AST registers
              "excl:CsrAllTests:CsrExclWrite" ],
      fields: [
        { bits: "31:0",
          name: "reg32",
          desc: "32-bit Register",
          resval: "0x2a",
        },
      ],
    }, //----------------------------------------------------------------------
    { name: "REGA43",
      desc: "AST 43 Register for OTP/ROM Write Testing",
      swaccess: "rw",
      hwaccess: "hro",
      tags: [ // don't write random data to any of the AST registers
              "excl:CsrAllTests:CsrExclWrite" ],
      fields: [
        { bits: "31:0",
          name: "reg32",
          desc: "32-bit Register",
          resval: "0x2b",
        },
      ],
    }, //----------------------------------------------------------------------
    { name: "REGA44",
      desc: "AST 44 Register for OTP/ROM Write Testing",
      swaccess: "rw",
      hwaccess: "hro",
      tags: [ // don't write random data to any of the AST registers
              "excl:CsrAllTests:CsrExclWrite" ],
      fields: [
        { bits: "31:0",
          name: "reg32",
          desc: "32-bit Register",
          resval: "0x2c",
        },
      ],
    }, //----------------------------------------------------------------------
    { name: "REGA45",
      desc: "AST 45 Register for OTP/ROM Write Testing",
      swaccess: "rw",
      hwaccess: "hro",
      tags: [ // don't write random data to any of the AST registers
              "excl:CsrAllTests:CsrExclWrite" ],
      fields: [
        { bits: "31:0",
          name: "reg32",
          desc: "32-bit Register",
          resval: "0x2d",
        },
      ],
    }, //----------------------------------------------------------------------
    { name: "REGA46",
      desc: "AST 46 Register for OTP/ROM Write Testing",
      swaccess: "rw",
      hwaccess: "hro",
      tags: [ // don't write random data to any of the AST registers
              "excl:CsrAllTests:CsrExclWrite" ],
      fields: [
        { bits: "31:0",
          name: "reg32",
          desc: "32-bit Register",
          resval: "0x2e",
        },
      ],
    }, //----------------------------------------------------------------------
    { name: "REGA47",
      desc: "AST 47 Register for OTP/ROM Write Testing",
      swaccess: "rw",
      hwaccess: "hro",
      tags: [ // don't write random data to any of the AST registers
              "excl:CsrAllTests:CsrExclWrite" ],
      fields: [
        { bits: "31:0",
          name: "reg32",
          desc: "32-bit Register",
          resval: "0x2f",
        },
      ],
    }, //----------------------------------------------------------------------
    { name: "REGA48",
      desc: "AST 48 Register for OTP/ROM Write Testing",
      swaccess: "rw",
      hwaccess: "hro",
      tags: [ // don't write random data to any of the AST registers
              "excl:CsrAllTests:CsrExclWrite" ],
      fields: [
        { bits: "31:0",
          name: "reg32",
          desc: "32-bit Register",
          resval: "0x30",
        },
      ],
    }, //----------------------------------------------------------------------
    { name: "REGA49",
      desc: "AST 49 Register for OTP/ROM Write Testing",
      swaccess: "rw",
      hwaccess: "hro",
      tags: [ // don't write random data to any of the AST registers
              "excl:CsrAllTests:CsrExclWrite" ],
      fields: [
        { bits: "31:0",
          name: "reg32",
          desc: "32-bit Register",
          resval: "0x31",
        },
      ],
    }, //----------------------------------------------------------------------
    { name: "REGA50",
      desc: "AST 50 Register for OTP/ROM Write Testing",
      swaccess: "rw",
      hwaccess: "hro",
      tags: [ // don't write random data to any of the AST registers
              "excl:CsrAllTests:CsrExclWrite" ],
      fields: [
        { bits: "31:0",
          name: "reg32",
          desc: "32-bit Register",
          resval: "0x32",
        },
      ],
    }, //----------------------------------------------------------------------
    { name: "REGA51",
      desc: "AST 51 Register for OTP/ROM Write Testing",
      swaccess: "rw",
      hwaccess: "hro",
      tags: [ // don't write random data to any of the AST registers
              "excl:CsrAllTests:CsrExclWrite" ],
      fields: [
        { bits: "31:0",
          name: "reg32",
          desc: "32-bit Register",
          resval: "0x33",
        },
      ],
    }, //----------------------------------------------------------------------
    { name: "REGA52",
      desc: "AST 52 Register for OTP/ROM Write Testing",
      swaccess: "rw",
      hwaccess: "hro",
      tags: [ // don't write random data to any of the AST registers
              "excl:CsrAllTests:CsrExclWrite" ],
      fields: [
        { bits: "31:0",
          name: "reg32",
          desc: "32-bit Register",
          resval: "0x34",
        },
      ],
    }, //----------------------------------------------------------------------
    { name: "REGAL",
      desc: "AST Last Register for OTP/ROM Write Testing",
      swaccess: "wo",
      hwaccess: "hrw",
      hwext:    "true",
      hwqe:     "true",
      tags: [ // don't write random data to any of the AST registers
              "excl:CsrAllTests:CsrExclAll" ],
      fields: [
        { bits: "31:0",
          name: "reg32",
          desc: "32-bit Register",
          resval: "0x35",
        },
      ],
    }, //----------------------------------------------------------------------
    ///////////////////////////////////////////////////////////////////////////
    { skipto: "0x200" }
    ///////////////////////////////////////////////////////////////////////////
    { multireg:
      {
        name: "REGB",
        desc: "AST Registers Array-B to set address space size",
        count: "NumRegsB",
        cname: "REGB",
        swaccess: "rw",
        hwaccess: "hro",
        tags: [ // don't write random data to any of the AST registers
                "excl:CsrAllTests:CsrExclAll" ],
        fields: [
          { bits: "31:0",
            name: "reg32",
            desc: "32-bit Register",
            resval: "0",
          },
        ],
      },
    }, //----------------------------------------------------------------------
  ],
}
