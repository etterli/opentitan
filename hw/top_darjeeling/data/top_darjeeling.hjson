// Copyright lowRISC contributors (OpenTitan project).
// Licensed under the Apache License, Version 2.0, see LICENSE for details.
// SPDX-License-Identifier: Apache-2.0
//
// TOP Darjeeling configuration
{ name: "darjeeling",
  type: "top",

  // 32-bit datawidth
  datawidth: "32",

  // Enable RACL on Darjeeling based on the following configuration
  racl_config: 'racl/racl.hjson'

  // Power information for the design
  power: {
    // Power domains supported by the design
    // Aon represents domain aon
    // 0 represents domain 0
    domains: ["Aon", "Main"],

    // Default power domain used for the design
    default: "Main"

    // Wait for external resets for integrated OpenTitan
    wait_for_external_reset: true

    // Ibex halt feature via additional ROM Control input
    halt_ibex_via_rom_ctrl: true
  },

  // List of unmanaged external clocks
  unmanaged_clocks: [
    // { name: "my_ext" }
  ]

  // This is the clock data structure of the design.
  // The src key indicates the raw clock sources in the design
  // The groups key indicates the various clock groupings in the design
  clocks: {

    // Clock Source attributes
    // name: Name of group.
    // aon:  Whether the clock is free running all the time.
    //       If it is, the clock is not handled by clkmgr.
    // freq: Absolute frequency of clk in Hz
    // ref: indicates the clock is used as a reference for measurement.
    srcs: [
      { name: "main", aon: "no",  freq: "1000000000" }
      { name: "io",   aon: "no",  freq: "250000000" }
      { name: "aon",  aon: "yes", freq: "62500000", ref: true}
    ],

    // Derived clock source attributes
    // name: Name of group.
    // aon:  Whether the clock is free running all the time.
    //       If it is, the clock is not handled by clkmgr.
    // freq: Absolute frequency of clk in Hz
    // src:  From which clock source is the clock derived
    // div:  Ratio between derived clock and source clock
    derived_srcs: [
    ],

    // Clock Group attributes
    // name: name of group.
    //
    // src: The hierarchical source of the clock
    // "ext"  - clock is supplied from a port of the top module
    // "top"  - clock is supplied from a net inside the top module
    //
    // sw_cg: whether software is allowed to gate the clock
    // "no"   - software is not allowed to gate clocks
    // "yes"  - software is allowed to gate clocks
    // "hint" - software can provide a hint, and hw controls the rest
    //
    // unique: whether each module in the group can be separately gated
    //         if sw_cg is "no", this field has no meaning
    // "yes"  - each clock is individually controlled
    // "no"   - the group is controlled as one single unit
    //
    // The powerup and proc groups are unique.
    // The powerup group of clocks do not feed through the clock
    // controller as they manage clock controller behavior
    // The proc group is not peripheral, and directly hardwired

    groups: [
      // the powerup group is used exclusively by clk/pwr/rstmgr/pinmux
      { name: "ast",     src:"ext", sw_cg: "no"                   }
      { name: "powerup", src:"top", sw_cg: "no"                   }
      { name: "trans",   src:"top", sw_cg: "hint", unique: "yes", }
      { name: "infra",   src:"top", sw_cg: "no",                  }
      { name: "secure",  src:"top", sw_cg: "no"                   }
      { name: "peri",    src:"top", sw_cg: "yes",  unique: "no"   }
      { name: "timers",  src:"top", sw_cg: "no"                   }
    ],
  },

  // This is the reset data structure of the design.
  // The node key represents all the known resets in the design
  resets: {

    // Reset node attributes
    // name: name of reset.
    //
    // gen: whether the reset is generated
    // true: it is a generated reset inside rstmgr
    // false: it is a hardwired design reset inside rstmgr (roots and por)
    // For non-generated resets, the parent / domain definitions have no meaning.
    //
    // type: the reset type [ext, top]
    // ext: the reset is coming in from the ports, external to darjeeling
    // int: the reset is only used inside rstmgr
    // top: the reset is output from rstmgr to top level struct
    //
    // parent: The parent reset
    // If type is "ext", there is no root, since it is external
    //
    // domains: The power domains of a particular reset
    // This is a list of the supported power domains.
    // Valid values are Aon and (power domain)0 ~ (power domain)1.
    // If no value is supplied, the default is specified by the power configuration.
    //
    // clk:  related clock domain for synchronous release
    // If type is "por", there is not related clock, since it is
    // likely external or generated from a voltage comparator
    //
    nodes: [
      { name: "por_aon",        gen: false, type: "top",                    clock: "aon"     }
      { name: "lc_src",         gen: false, type: "int",                    clock: "io" }
      { name: "sys_src",        gen: false, type: "int",                    clock: "io" }
      { name: "por",            gen: true,  type: "top", parent: "por_aon", clock: "main"    }
      { name: "por_io",         gen: true,  type: "top", parent: "por_aon", clock: "io"      }
      { name: "lc",             gen: true,  type: "top", parent: "lc_src",  clock: "main"    }
      { name: "lc_aon",         gen: true,  type: "top", parent: "lc_src",  clock: "aon"     }
      { name: "lc_io",          gen: true,  type: "top", parent: "lc_src",  clock: "io"      }
      { name: "sys",            gen: true,  type: "top", parent: "sys_src", clock: "main"    }
      { name: "spi_device",     gen: true,  type: "top", parent: "lc_src", clock: "io", sw: true }
      { name: "spi_host0",      gen: true,  type: "top", parent: "lc_src", clock: "io", sw: true }
      { name: "i2c0",           gen: true,  type: "top", parent: "lc_src", clock: "io", sw: true },
    ]
  }
  // The reset requests: peripherals are deduced, but internal and debug need
  // to be configure in hjson file.
  reset_requests: {
    int: [
      {
        "name": "MainPwr",
        "desc": "main power glitch reset request",
        "module": "pwrmgr"
      },
      {
        "name": "Esc",
        "desc": "escalation reset request",
        "module": "alert_handler"
      }
    ],
    debug: [
      {
        "name": "Ndm",
        "desc": "non-debug-module reset request",
        "module": "rv_dm"
      }
    ],
  },
  // Number of cores: used in rv_plic and timer
  num_cores: "1",

  // Any module with interrupts that doesn't specify plic
  // will have its interrupts sent here
  default_plic: "rv_plic"

  // Any module with alerts that doesn't specify alert_handler
  // will have its alerts sent here
  default_alert_handler: "alert_handler"

  // `addr_spaces` names the distinct address spaces present in the device.
  // All hosts in the same address space share the same base addresses for
  // all peripherals, though not every peripheral will be accessible to every
  // host in that address space--Access privileges are separate from addresses.
  addr_spaces: [
    { name: "hart"
      desc: "The main address space, shared between the CPU and DM"
      subspaces: [
        { name: "mmio",
          desc: '''
                MMIO region excludes any memory that is separate from the module configuration
                space, i.e. ROM, main SRAM, and mbx SRAM are excluded but retention SRAM or
                spi_device are included.
                '''
          nodes: [
            "uart0",
            "gpio0",
            "spi_device",
            "i2c0",
            "rv_timer",
            "otp_ctrl",
            "lc_ctrl.regs",
            "alert_handler",
            "spi_host0",
            "pwrmgr",
            "rstmgr",
            "clkmgr",
            "pinmux",
            "aon_timer",
            "ast"
            "soc_proxy.core",
            "soc_dbg_ctrl.core",
            "sram_ctrl_ret",
            "rv_plic",
            "aes",
            "hmac",
            "otbn",
            "keymgr_dpe"
            "csrng",
            "entropy_src",
            "edn0",
            "edn1",
            "sram_ctrl_main.regs",
            "sram_ctrl_mbox.regs",
            "rom_ctrl0.regs",
            "rom_ctrl1.regs",
            "dma",
            "mbx0.core",
            "mbx1.core",
            "mbx2.core",
            "mbx3.core",
            "mbx4.core",
            "mbx5.core",
            "mbx6.core",
            "mbx_jtag.core",
            "mbx_pcie0.core",
            "mbx_pcie1.core",
            "rv_core_ibex"
          ],
        },
      ]
    }
    { name: "soc_mbx", desc: "SoC address space for mailbox access"},
    { name: "soc_dbg", desc: "SoC address space for debug module interfaces"},
  ]

  // `module` defines the peripherals.
  // Details are coming from each modules' config file `ip.hjson`
  // TODO: Define parameter here
  // attr: There are a few types of modules supported
     //   normal(default): Normal, non-templated modules that will be instantiated
     //   templated:   These modules are templated and must be run through topgen
     //   ipgen:       These modules are the same as templated but use the new ipgen flow
     //   reggen_top:  These modules are not templated, but need to have reggen run
     //                because they live exclusively in hw/top_* instead of hw/ip_*.
     //                These modules are also instantiated in the top level.
     //   reggen_only: Similar to reggen_top, but are not instantiated in the top level.
  module: [
    { name: "uart0",    // instance name
      type: "uart",     // Must be matched to the ip name in `ip.hjson` (_reg, _cfg permitted)
                        // and `hw/ip/{type}`

      // clock connections defines the port to top level clock connection
      // the ip.hjson will declare the clock port names
      // If none are defined at ip.hjson, clk_i is used by default
      clock_srcs: {clk_i: "io"},
      clock_group: "peri",
      // reset connections defines the port to top level reset connection
      // the ip.hjson will declare the reset port names
      // If none are defined at ip.hjson, rst_ni is used by default
      reset_connections: {rst_ni: "lc_io"},
      base_addr: {
        hart: "0x30010000",
      },
    },
    { name: "gpio0",
      type: "gpio",
      template_type: "gpio",
      clock_srcs: {clk_i: "io"},
      clock_group: "peri",
      reset_connections: {rst_ni: "lc_io"},
      base_addr: {
        hart: "0x30000000",
      },
      param_decl: {
        GpioAsHwStrapsEn: "1",
        GpioAsyncOn: "1"
      },
      ipgen_params: {
        num_inp_period_counters: 8
      }
      attr: "ipgen"
    },
    { name: "spi_device",
      type: "spi_device",
      clock_srcs: {clk_i: "io", scan_clk_i: "io"},
      clock_group: "peri",
      reset_connections: {rst_ni: "spi_device"},
      base_addr: {
        hart: "0x30310000",
      },
      param_decl: {
        "SramType": "spi_device_pkg::SramType1r1w"
      }
    },
    { name: "i2c0",
      type: "i2c",
      clock_srcs: {clk_i: "io"},
      clock_group: "peri",
      reset_connections: {rst_ni: "i2c0"},
      base_addr: {
        hart: "0x30080000",
      },
    },
    { name: "rv_timer",
      type: "rv_timer",
      clock_srcs: {clk_i: "io"},
      clock_group: "timers",
      reset_connections: {rst_ni: "lc_io"},
      base_addr: {
        hart: "0x30100000",
      },
    },
    { name: "otp_ctrl",
      type: "otp_ctrl",
      template_type: "otp_ctrl",
      clock_srcs: {clk_i: "io", clk_edn_i: "main"},
      clock_group: "secure",
      reset_connections: {rst_ni: "lc_io", rst_edn_ni: "lc"},
      base_addrs: {
        core: {hart: "0x30130000"},
      }
      attr: "ipgen",
    },
    {
      name: "otp_macro",
      type: "otp_macro",
      clock_srcs: {clk_i: "io"},
      clock_group: "secure",
      reset_connections: {rst_ni: "lc_io"},
      base_addrs: {
        prim: {hart: "0x30140000"},
      },
      param_decl: {
        Width: "otp_ctrl_macro_pkg::OtpWidth",
        Depth: "otp_ctrl_macro_pkg::OtpDepth",
        SizeWidth: "otp_ctrl_macro_pkg::OtpSizeWidth",
        VendorTestOffset: "otp_ctrl_reg_pkg::VendorTestOffset",
        VendorTestSize: "otp_ctrl_reg_pkg::VendorTestSize",
      },
    },
    { name: "lc_ctrl",
      type: "lc_ctrl",
      clock_srcs: {clk_i: "io", clk_kmac_i: "main"},
      clock_group: "secure",
      reset_connections: {rst_ni: "lc_io", rst_kmac_ni: "lc"},
      base_addrs: {
        regs: {hart: "0x30150000"},
        dmi:  {soc_dbg: "0x3000"},
      },
      param_decl: {
        // NOTE THAT THIS IS A FEATURE FOR TEST CHIPS ONLY TO MITIGATE
        // THE RISK OF A BROKEN OTP MACRO. THIS WILL BE DISABLED FOR
        // PRODUCTION DEVICES.
        SecVolatileRawUnlockEn: "top_pkg::SecVolatileRawUnlockEn",
        // The following three values get exposed in the life cycle CSRs
        // that are also readable via the TAP.
        SiliconCreatorId: "16'h 4002", // Darjeeling integration with Rivos
        ProductId: "16'h 4000", // Darjeeling
        RevisionId: "8'h 01",   // First tapeout
        // Use TL-UL based DMI
        UseDmiInterface: "1",
        // Only use 1 RMI interface
        NumRmaAckSigs: "1"
        EscNumSeverities: "AlertHandlerEscNumSeverities",
        EscPingCountWidth: "AlertHandlerEscPingCountWidth",
      },
    },
    { name: "alert_handler",
      type: "alert_handler",
      template_type: "alert_handler",
      clock_srcs: {clk_i: "io", clk_edn_i: "main"},
      clock_group: "secure",
      reset_connections: {rst_ni: "lc_io", rst_edn_ni: "lc"},
      base_addr: {
        hart: "0x30160000",
      },
      param_decl: {
        EscNumSeverities: "4",
        EscPingCountWidth: "16"
      },
      attr: "ipgen",
    },
    { name: "spi_host0",
      type: "spi_host",
      clock_srcs: {clk_i: "io"},
      clock_group: "peri",
      reset_connections: {rst_ni: "spi_host0"},
      base_addr: {
        hart: "0x30300000",
      },
    },
    { name: "pwrmgr",
      type: "pwrmgr",
      template_type: "pwrmgr",
      clock_group: "powerup",
      clock_srcs: {
        clk_i: "io",
        clk_slow_i: "aon",
        clk_lc_i: "io",
        clk_esc_i: {
          clock: "io",
          group: "secure"
        }
      },
      reset_connections: {
        rst_ni: {
          name: "por_io",
          domain: "Aon"
        },
        rst_main_ni: {
          name: "por_aon",
          domain: "Main"
        },
        rst_lc_ni: {
          name: "lc_io",
          domain: "Aon"
        },
        rst_esc_ni: {
          name: "lc_io",
          domain: "Aon"
        },
        rst_slow_ni: {
          name: "por_aon",
          domain: "Aon",
        },
      }
      domain: "Aon",
      base_addr: {
        hart: "0x30400000",
      },
      param_decl: {
        EscNumSeverities: "AlertHandlerEscNumSeverities",
        EscPingCountWidth: "AlertHandlerEscPingCountWidth",
      },
      attr: "ipgen",

    },
    { name: "rstmgr",
      type: "rstmgr",
      template_type: "rstmgr",
      clock_srcs: {
        clk_i: {
          clock: "io",
          group: "powerup"
        },
        clk_por_i: "io", clk_aon_i: "aon", clk_main_i: "main", clk_io_i: "io"
      },
      clock_group: "powerup",
      reset_connections: {
        rst_ni: {
          name: "lc_io",
          domain: "Aon"
        },
        rst_por_ni: {
          name: "por_io",
          domain: "Aon"
        },
      }
      domain: "Aon",
      base_addr: {
        hart: "0x30410000",
      },
      attr: "ipgen",
    },
    { name: "clkmgr",
      type: "clkmgr",
      template_type: "clkmgr",
      clock_srcs: {
        clk_i: "io",
        clk_main_i: {
          group: "ast",
          clock: "main"
        },
        clk_io_i: {
          group: "ast",
          clock: "io"
        },
        clk_aon_i: {
          group: "ast",
          clock: "aon"
        }
      },
      clock_group: "powerup",
      reset_connections: {rst_ni: "lc_io",
                          rst_aon_ni: "lc_aon"
                          rst_io_ni: "lc_io",
                          rst_main_ni: "lc",
                          rst_root_ni: "por_io",
                          rst_root_io_ni: "por_io",
                          rst_root_main_ni: "por",
                         },
      domain: "Aon",
      base_addr: {
        hart: "0x30420000",
      },
      ipgen_params: {
        ext_clk_bypass: false
      },
      attr: "ipgen",
    },
    { name: "pinmux",
      type: "pinmux",
      template_type: "pinmux",
      clock_srcs: {
        primary: {clk_i: "io", clk_aon_i: "aon"},
        secondary: {clk_i: "io"},
      },
      clock_group: {primary: "powerup", secondary: "powerup"},
      reset_connections: {
        primary: {
          rst_ni: {
            name: "lc_io",
            domain: "Aon"
          },
          rst_aon_ni: {
            name: "lc_aon",
            domain: "Aon"
          },
        },
        secondary: {
          rst_ni: {
            name: "lc_io",
            domain: "Aon"
          },
        },
      },
      domain: "Main",
      domain_secondary: "Aon",
      base_addr: {
        hart: "0x30460000",
      },
      attr: "ipgen",
    },
    { name: "aon_timer",
      type: "aon_timer",
      clock_srcs: {clk_i: "io", clk_aon_i: "aon"},
      clock_group: "timers",
      reset_connections: {rst_ni: "lc_io", rst_aon_ni: "lc_aon"},
      domain: "Aon",
      base_addr: {
        hart: "0x30470000",
      },
    },
    { name: "ast",
      type: "ast",
      clock_srcs: {
        clk_ast_tlul_i: {
          clock: "io",
          group: "infra"
        },
        clk_ast_alert_i: {
          clock: "io",
          group: "secure"
        }
        clk_ast_rng_i: {
          clock: "main",
          group: "secure"
        }
      },
      clock_group: "secure",
      reset_connections: {
        rst_ast_tlul_ni: {
          name: "lc_io",
          domain: "Main",
        }
        rst_ast_alert_ni: {
          name: "lc_io",
          domain: "Main",
        },
        rst_ast_rng_ni: {
          name: "lc",
          domain: "Main",
        },
      },
      domain: "Main",
      base_addr: {
        hart: "0x30480000",
      },
      attr: "reggen_only",
    },
    { name: "soc_proxy",
      type: "soc_proxy",
      clock_srcs: {clk_i: "main", clk_aon_i: "aon"},
      clock_group: "infra",
      reset_connections: {
        rst_ni: {
          name: "lc",
          domain: "Main",
        },
        rst_por_ni: {
          name: "por_io",
          domain: "Aon",
        },
      },
      domain: "Aon",
      base_addrs: {
        core: {hart: "0x22030000"},
        ctn:  {hart: "0x40000000"},
      },
      attr: "reggen_top",
      memory: {
        ctn: {
          label: "ctn",
          swaccess: "rw",
          data_intg_passthru: "true",
          exec: "True",
          byte_write: "True",
          size: "0x80000000",
        }
      }
    },
    { name: "sram_ctrl_ret",
      type: "sram_ctrl",
      clock_srcs: {clk_i: "io", clk_otp_i: "io"},
      clock_group: "infra",
      reset_connections: {rst_ni: "lc_io", rst_otp_ni: "lc_io"}
      domain: "Aon",
      param_decl: {
        InstrExec: "0",
        InstSize: 4096
      }
      base_addrs: {
        regs: {hart: "0x30500000"},
        ram:  {hart: "0x30600000"},
      },
      // Memory regions must be associated with a dedicated
      // TL-UL device interface.
      memory: {
        ram: {
          label:    "ram_ret_aon",
          swaccess:   "rw",
          data_intg_passthru: "true",
          exec:       "True",
          byte_write: "True",
          size:     "0x1000"
        }
      }
    },
    { name: "rv_dm",
      type: "rv_dm",
      clock_srcs: {clk_i: "main", clk_lc_i: "main"},
      clock_group: "infra",
      reset_connections: {rst_ni: "sys", rst_lc_ni: "lc"},
      // Note that this module also contains a bus host.
      base_addrs: {
        mem:  {hart: "0x00040000"},
        regs: {hart: "0x21200000"},
        dbg:  {soc_dbg: "0x00000000"},
      },
      param_decl: {
        // NOTE THAT THIS IS A FEATURE FOR TEST CHIPS ONLY TO MITIGATE
        // THE RISK OF A BROKEN OTP MACRO. THIS WILL BE DISABLED FOR
        // PRODUCTION DEVICES.
        SecVolatileRawUnlockEn: "top_pkg::SecVolatileRawUnlockEn",
        // Use TL-UL based DMI
        UseDmiInterface: "1"
      },
      generate_dif: "False"
    },
    { name: "rv_plic",
      type: "rv_plic",
      template_type: "rv_plic",
      clock_srcs: {clk_i: "main"},
      clock_group: "secure",
      reset_connections: {rst_ni: "lc"},
      base_addr: {
        hart: "0x28000000",
      },
      attr: "ipgen",
      targets: ["rv_core_ibex"]
    },
    { name: "aes",
      type: "aes",
      clock_srcs: {clk_i: "main", clk_edn_i: "main"},
      clock_group: "trans",
      reset_connections: {rst_ni: "lc", rst_edn_ni: "lc"},
      param_decl: {
        AESGCMEnable: "1",
        SecMasking: "1",
        SecSBoxImpl: "aes_pkg::SBoxImplDom"
      }
      base_addr: {
        hart: "0x21100000",
      },
    },
    { name: "hmac",
      type: "hmac",
      clock_srcs: {clk_i: "main"},
      clock_group: "trans",
      reset_connections: {rst_ni: "lc"},
      base_addr: {
        hart: "0x21110000",
      },
    },
    { name: "kmac",
      type: "kmac",
      param_decl: {
        EnMasking: "1",
        NumAppIntf: 4,
        AppCfg: "'{kmac_pkg::AppCfgKeyMgr,\n        kmac_pkg::AppCfgLcCtrl,\n        kmac_pkg::AppCfgRomCtrl,\n        kmac_pkg::AppCfgRomCtrl}"
      }
      clock_srcs: {clk_i: "main", clk_edn_i: "main"}
      clock_group: "trans"
      reset_connections: {rst_ni: "lc", rst_edn_ni: "lc"}
      base_addr: {
        hart: "0x21120000",
      }
    },
    { name: "otbn",
      type: "otbn",
      clock_srcs: {
        clk_i: {
          clock: "main",
          group: "trans"
        },
        clk_edn_i: {
          clock: "main",
          group: "secure"
        },
        clk_otp_i: {
          clock: "io",
          group: "secure"
        },
      },
      clock_group: "trans",
      reset_connections: {rst_ni: "lc", rst_edn_ni: "lc", rst_otp_ni: "lc_io"},
      base_addr: {
        hart: "0x21130000",
      },
    },
    { name: "keymgr_dpe",
      type: "keymgr_dpe",
      clock_srcs: {clk_i: "main", clk_edn_i: "main"},
      clock_group: "secure",
      reset_connections: {rst_ni: "lc", rst_edn_ni: "lc"},
      base_addr: {
        hart: "0x21140000",
      },
      param_decl: {
        NumInstHwSlot: "8",
        NumBootStages: "2",
        NumRomDigestInputs: "2",
        KdfEngineSel: "keymgr_dpe_pkg::KdfEngineBoth",
      },
    },
    { name: "csrng",
      type: "csrng",
      clock_srcs: {clk_i: "main"},
      clock_group: "secure",
      reset_connections: {rst_ni: "lc"},
      base_addr: {
        hart: "0x21150000",
      },
    },
    { name: "entropy_src",
      type: "entropy_src",
      clock_srcs: {clk_i: "main"},
      clock_group: "secure",
      reset_connections: {rst_ni: "lc"},
      base_addr: {
        hart: "0x21160000",
      },
      param_decl: {
        RngBusWidth: "16",
        RngBusBitSelWidth: "4",
        HealthTestWindowWidth: "20",
        // On Darjeeling, in worst case, there is a new 16-bit entropy word from the RNG every 3
        // cycles. Based on the back pressure formula in the entropy_src, this yields a depth of 11.
        DistrFifoDepth: "11",
      },
    },
    { name: "edn0",
      type: "edn",
      clock_srcs: {clk_i: "main"},
      clock_group: "secure",
      reset_connections: {rst_ni: "lc"},
      base_addr: {
        hart: "0x21170000",
      },
      param_decl: {
        NumEndPoints: "8",
      },
    },
    { name: "edn1",
      type: "edn",
      clock_srcs: {clk_i: "main"},
      clock_group: "secure",
      reset_connections: {rst_ni: "lc"},
      base_addr: {
        hart: "0x21180000",
      },
      param_decl: {
        NumEndPoints: "1",
      },
    },
    { name: "sram_ctrl_main",
      type: "sram_ctrl",
      clock_srcs: {clk_i: "main", clk_otp_i: "io"},
      clock_group: "infra",
      reset_connections: {rst_ni: "lc", rst_otp_ni: "lc_io"},
      // Note that while it might be useful to allow execution from SRAM for early testing, it can
      // later be permanently disabled using the EN_SRAM_IFETCH switch in OTP.
      param_decl: {
        InstrExec: "1",
        InstSize: 65536
      }
      base_addrs: {
        regs: {hart: "0x211c0000"},
        ram:  {hart: "0x10000000"},
      },
      // Memory regions must be associated with a dedicated
      // TL-UL device interface.
      memory: {
        ram: {
          label:      "ram_main",
          swaccess:   "rw",
          data_intg_passthru: "true",
          exec:       "True",
          byte_write: "True",
          size:       "0x10000"
        }
      }
    },
    { name: "sram_ctrl_mbox",
      type: "sram_ctrl",
      clock_srcs: {clk_i: "main", clk_otp_i: "io"},
      clock_group: "infra",
      reset_connections: {rst_ni: "lc", rst_otp_ni: "lc_io"},
      param_decl: {
        InstrExec: "0",
        InstSize: 4096
      }
      base_addrs: {
        regs: {hart: "0x211d0000"},
        ram:  {hart: "0x11000000"},
      },
      // Memory regions must be associated with a dedicated
      // TL-UL device interface.
      memory: {
        ram: {
          label:    "ram_mbox",
          swaccess:   "rw",
          data_intg_passthru: "true",
          exec:       "False",
          byte_write: "True",
          size:     "0x1000"
        }
      }
    },
    { name: "rom_ctrl0",
      type: "rom_ctrl",
      clock_srcs: {clk_i: "main"},
      clock_group: "infra",
      reset_connections: {rst_ni: "lc"},
      base_addrs: {
        rom:  {hart: "0x00008000"},
        regs: {hart: "0x211e0000"},
      }
      memory: {
        rom: {
          label:              "rom0",
          swaccess:           "ro",
          data_intg_passthru: "true",
          exec:               "True",
          byte_write:         "False",
          size:               "0x8000"
          data_intg_passthru: "True"
        }
      },
      param_decl: {
        SecDisableScrambling: "1'b0",
        FlopToKmac: "1'b1"
      }
    },
    { name: "rom_ctrl1",
      type: "rom_ctrl",
      clock_srcs: {clk_i: "main"},
      clock_group: "infra",
      reset_connections: {rst_ni: "lc"},
      // TODO(opentitan-integrated/issues/251):
      // This is not the final parameterization for Darjeeling.
      base_addrs: {
        rom:  {hart: "0x00020000"},
        regs: {hart: "0x211e1000"},
      }
      memory: {
        rom: {
          label:              "rom1",
          swaccess:           "ro",
          data_intg_passthru: "true",
          exec:               "True",
          byte_write:         "False",
          size:               "0x10000"
          data_intg_passthru: "True"
        }
      },
      param_decl: {
        SecDisableScrambling: "1'b0",
        FlopToKmac: "1'b1"
      }
    },
    { name: "dma",
      type: "dma",
      clock_srcs: {clk_i: "main"}
      clock_group: "infra",
      reset_connections: {rst_ni: "lc"},
      base_addr: {hart: "0x22010000"},
    },
    { name: "mbx0",
      type: "mbx",
      clock_srcs: {clk_i: "main"}
      clock_group: "infra",
      reset_connections: {rst_ni: "lc"},
      base_addrs: {
        core: {hart: "0x22000000"},
        soc:  {soc_mbx: "0x01465000"},
      },
      racl_mappings: {
        soc: 'racl/all_rd_wr_mapping.hjson'
      }
    },
    { name: "mbx1",
      type: "mbx",
      clock_srcs: {clk_i: "main"}
      clock_group: "infra",
      reset_connections: {rst_ni: "lc"},
      base_addrs: {
        core: {hart: "0x22000100"},
        soc:  {soc_mbx: "0x01465100"},
      },
      racl_mappings: {
        soc: 'racl/all_rd_wr_mapping.hjson'
      }
    },
    { name: "mbx2",
      type: "mbx",
      clock_srcs: {clk_i: "main"}
      clock_group: "infra",
      reset_connections: {rst_ni: "lc"},
      base_addrs: {
        core: {hart: "0x22000200"},
        soc:  {soc_mbx: "0x01465200"},
      },
      racl_mappings: {
        soc: 'racl/all_rd_wr_mapping.hjson'
      }
    },
    { name: "mbx3",
      type: "mbx",
      clock_srcs: {clk_i: "main"}
      clock_group: "infra",
      reset_connections: {rst_ni: "lc"},
      base_addrs: {
        core: {hart: "0x22000300"},
        soc:  {soc_mbx: "0x01465300"},
      },
      racl_mappings: {
        soc: 'racl/all_rd_wr_mapping.hjson'
      }
    },
    { name: "mbx4",
      type: "mbx",
      clock_srcs: {clk_i: "main"}
      clock_group: "infra",
      reset_connections: {rst_ni: "lc"},
      base_addrs: {
        core: {hart: "0x22000400"},
        soc:  {soc_mbx: "0x01465400"},
      },
      racl_mappings: {
        soc: 'racl/all_rd_wr_mapping.hjson'
      }
    },
    { name: "mbx5",
      type: "mbx",
      clock_srcs: {clk_i: "main"}
      clock_group: "infra",
      reset_connections: {rst_ni: "lc"},
      base_addrs: {
        core: {hart: "0x22000500"},
        soc:  {soc_mbx: "0x01465500"},
      },
      racl_mappings: {
        soc: 'racl/all_rd_wr_mapping.hjson'
      }
    },
    { name: "mbx6",
      type: "mbx",
      clock_srcs: {clk_i: "main"}
      clock_group: "infra",
      reset_connections: {rst_ni: "lc"},
      base_addrs: {
        core: {hart: "0x22000600"},
        soc:  {soc_mbx: "0x01496000"},
      },
      racl_mappings: {
        soc: 'racl/all_rd_wr_mapping.hjson'
      }
    },
    { name: "mbx_jtag",
      type: "mbx",
      clock_srcs: {clk_i: "main"}
      clock_group: "infra",
      reset_connections: {rst_ni: "lc"},
      base_addrs: {
        core: {hart: "0x22000800"},
        soc:  {soc_dbg: "0x2200"},
      },
      racl_mappings: {
        soc: 'racl/all_rd_wr_mapping.hjson'
      }
    },
    { name: "mbx_pcie0",
      type: "mbx",
      clock_srcs: {clk_i: "main"}
      clock_group: "infra",
      reset_connections: {rst_ni: "lc"},
      base_addrs: {
        core: {hart: "0x22040000"},
        soc:  {soc_mbx: "0x01460100"},
      },
      racl_mappings: {
        soc: 'racl/soc_rot_mapping.hjson'
      }
    },
    { name: "mbx_pcie1",
      type: "mbx",
      clock_srcs: {clk_i: "main"}
      clock_group: "infra",
      reset_connections: {rst_ni: "lc"},
      base_addrs: {
        core: {hart: "0x22040100"},
        soc:  {soc_mbx: "0x01460200"},
      },
      racl_mappings: {
        soc: 'racl/soc_rot_mapping.hjson'
      }
    },
    { name: "soc_dbg_ctrl",
      type: "soc_dbg_ctrl",
      clock_srcs: {clk_i: "io"},
      clock_group: "secure",
      reset_connections: {rst_ni: "lc_io"},
      base_addrs: {
        core:  {hart: "0x30170000"},
        jtag:  {soc_dbg: "0x2300"},
      },
    },
    { name: "racl_ctrl",
      type: "racl_ctrl",
      template_type: "racl_ctrl",
      clock_srcs: {clk_i: "main"}
      clock_group: "infra",
      reset_connections: {rst_ni: "lc"},
      base_addr: {
        soc_mbx: "0x01461f00",
      },
      attr: "ipgen"
    },
    { name: "ac_range_check",
      type: "ac_range_check",
      template_type: "ac_range_check",
      clock_srcs: {clk_i: "main"},
      clock_group: "secure",
      reset_connections: {rst_ni: "lc"},
      base_addr: {
        soc_mbx: "0x01464000"
      },
      ipgen_params: {
        num_ranges: 32
      }
      attr: "ipgen",
      racl_mapping: 'racl/soc_rot_mapping.hjson'
    },
    { name: "rv_core_ibex",
      type: "rv_core_ibex",
      template_type: "rv_core_ibex",
      attr: "ipgen",
      ipgen_params: {
        num_regions: 32
      }
      param_decl: {PMPEnable: "1",
                   PMPGranularity: "0",
                   PMPNumRegions: "16",
                   MHPMCounterNum: "10",
                   MHPMCounterWidth: "32",
                   PMPRstCfg: "ibex_pmp_reset_pkg::PmpCfgRst",
                   PMPRstAddr: "ibex_pmp_reset_pkg::PmpAddrRst",
                   PMPRstMsecCfg: "ibex_pmp_reset_pkg::PmpMseccfgRst",
                   RV32E: "0",
                   RV32M: "ibex_pkg::RV32MSingleCycle",
                   RV32B: "ibex_pkg::RV32BFull",
                   RV32ZC: "ibex_pkg::RV32ZcaZcbZcmp",
                   RegFile: "ibex_pkg::RegFileFF",
                   BranchTargetALU: "1",
                   WritebackStage: "1",
                   ICache: "1",
                   ICacheECC: "1",
                   ICacheScramble: "1",
                   BranchPredictor: "0",
                   DbgTriggerEn: "1",
                   DbgHwBreakNum: "4",
                   SecureIbex: "1",
                   DmBaseAddr: "tl_main_pkg::ADDR_SPACE_RV_DM__MEM",
                   DmAddrMask: "tl_main_pkg::ADDR_MASK_RV_DM__MEM",
                   DmHaltAddr: "tl_main_pkg::ADDR_SPACE_RV_DM__MEM + dm::HaltAddress[31:0]",
                   DmExceptionAddr: "tl_main_pkg::ADDR_SPACE_RV_DM__MEM + dm::ExceptionAddress[31:0]",
                   PipeLine: "1",
                   InstructionPipeline: "1",
                   NEscalationSeverities: "AlertHandlerEscNumSeverities",
                   WidthPingCounter: "AlertHandlerEscPingCountWidth",
                  },
      clock_srcs: {
        clk_i: "main",
        clk_edn_i: "main",
        clk_esc_i: {
          clock: "io",
          group: "secure",
        }
        clk_otp_i: {
          clock: "io",
          group: "secure",
        }
      },
      clock_group: "infra",
      reset_connections: {rst_ni: "lc",
                          rst_edn_ni: "lc",
                          rst_esc_ni: "lc_io",
                          rst_otp_ni: "lc_io"},
      base_addr: {
        hart: "0x211f0000",
      },
    },
  ]

  // The port data structure is not something that should be used liberally.
  // It is used specifically to assign special attributes to specific ports.
  // For example, this allows us to designate a port as part of inter-module
  // connections.
  port: [
    { name: "ast",
      inter_signal_list: [
        { struct: "lc_tx",
          type: "uni",
          name: "lc_dft_en",
          // The activity direction for a port inter-signal is "opposite" of
          // what the external module actually needs.
          act:  "req",
          package: "lc_ctrl_pkg",
        },

        { struct: "lc_tx",
          type: "uni",
          name: "lc_hw_debug_en",
          // The activity direction for a port inter-signal is "opposite" of
          // what the external module actually needs.
          act:  "req",
          package: "lc_ctrl_pkg",
        },

        { struct: "ast_obs_ctrl",
          type: "uni",
          name: "obs_ctrl",
          // The activity direction for a port inter-signal is "opposite" of
          // what the external module actually needs.
          act:  "rcv",
          package: "ast_pkg",
        },
      ]
    },
  ]

  // Inter-module Connection.
  // format:
  //    requester: [ resp1, resp2, ... ],
  //
  //  the field and value should be module_inst.port_name
  //  e.g flash_ctrl0.flash: [flash_phy0.flash_ctrl]
  inter_module: {
    'connect': {
      'ast.obs_ctrl'            : ['otp_macro.obs_ctrl']
      'alert_handler.crashdump' : ['rstmgr.alert_dump'],
      'alert_handler.esc_rx'    : ['rv_core_ibex.esc_rx',
                                   'lc_ctrl.esc_scrap_state0_rx',
                                   'lc_ctrl.esc_scrap_state1_rx'
                                   'pwrmgr.esc_rst_rx'],
      'alert_handler.esc_tx'    : ['rv_core_ibex.esc_tx',
                                   'lc_ctrl.esc_scrap_state0_tx',
                                   'lc_ctrl.esc_scrap_state1_tx',
                                   'pwrmgr.esc_rst_tx'],
      'aon_timer.nmi_wdog_timer_bark' : ['rv_core_ibex.nmi_wdog']
      'csrng.csrng_cmd'         : ['edn0.csrng_cmd', 'edn1.csrng_cmd'],
      'csrng.entropy_src_hw_if' : ['entropy_src.entropy_src_hw_if'],
      'otp_ctrl.sram_otp_key'   : ['sram_ctrl_main.sram_otp_key',
                                   'sram_ctrl_ret.sram_otp_key',
                                   'sram_ctrl_mbox.sram_otp_key'
                                   'rv_core_ibex.icache_otp_key']
      'pwrmgr.pwr_rst'          : ['rstmgr.pwr'],
      'pwrmgr.pwr_clk'          : ['clkmgr.pwr'],
      'pwrmgr.pwr_otp'          : ['otp_ctrl.pwr_otp'],
      'pwrmgr.pwr_lc'           : ['lc_ctrl.pwr_lc'],
      'pwrmgr.strap'            : ['gpio0.strap_en',
                                   'rv_dm.strap_en'],
      'pwrmgr.low_power'        : ['pinmux.sleep_en',
                                   'aon_timer.sleep_mode'],
      'pwrmgr.fetch_en'         : ['rv_core_ibex.pwrmgr_cpu_en'],
      'pwrmgr.rom_ctrl'         : ['rom_ctrl0.pwrmgr_data',
                                   'rom_ctrl1.pwrmgr_data',
                                   'soc_dbg_ctrl.continue_cpu_boot'],
      'pwrmgr.boot_status'      : ['soc_dbg_ctrl.boot_status'],
      'keymgr_dpe.rom_digest'   : ['rom_ctrl0.keymgr_data',
                                   'rom_ctrl1.keymgr_data'],
      'alert_handler.crashdump' : ['rstmgr.alert_dump'],

      // DMA LSIO triggers
      'dma.lsio_trigger'        : ['soc_proxy.dma_lsio_trigger'],
      'i2c0.lsio_trigger'       : ['soc_proxy.i2c_lsio_trigger'],
      'spi_host0.lsio_trigger'  : ['soc_proxy.spi_host_lsio_trigger'],
      'uart0.lsio_trigger'      : ['soc_proxy.uart_lsio_trigger'],

      // LC RMA req/ack interface: LC -> OTBN
      // Note: this RoT configuration has no embedded nvm, hence
      // the RMA request is just routed to OTBN directly.
      'lc_ctrl.lc_nvm_rma_req'   : ['otbn.lc_rma_req'],
      'otbn.lc_rma_ack'          : ['lc_ctrl.lc_nvm_rma_ack'],

      // Edn connections
      'edn0.edn'              : ['keymgr_dpe.edn', 'otp_ctrl.edn', 'kmac.entropy',
                                 'alert_handler.edn', 'aes.edn', 'otbn.edn_urnd',
                                 'rv_core_ibex.edn'],
      'edn1.edn'              : ['otbn.edn_rnd'],

      // OTBN OTP scramble key
      'otp_ctrl.otbn_otp_key' : ['otbn.otbn_otp_key'],

      // KeyMgr DPE Sideload & KDF function
      'otp_ctrl.keymgr_creator_root_key'  : ['keymgr_dpe.creator_root_key'],
      'otp_ctrl.keymgr_creator_seed'      : ['keymgr_dpe.creator_seed'],
      'otp_ctrl.keymgr_owner_seed'        : ['keymgr_dpe.owner_seed'],
      'keymgr_dpe.aes_key'                : ['aes.keymgr_key'],
      'keymgr_dpe.kmac_key'               : ['kmac.keymgr_key'],
      'keymgr_dpe.hmac_key'               : ['hmac.keymgr_key'],
      'keymgr_dpe.otbn_key'               : ['otbn.keymgr_key'],

      // KMAC Application Interface
      // Note that arbitration is fixed priority top to bottom.
      'kmac.app'                : ['keymgr_dpe.kmac_app',  // Keymgr needs to be at index 0
                                   'lc_ctrl.kmac_data',    // LC needs to be at index 1
                                   'rom_ctrl0.kmac_data',  // ROM needs to be at index 2 or 3
                                   'rom_ctrl1.kmac_data'], // ROM needs to be at index 2 or 3
      'kmac.en_masking'         : ['keymgr_dpe.kmac_en_masking']

      // OTBN Application Interface
      'otbn.keymgr_app'           : ['keymgr_dpe.otbn_app'],
      'otbn.keymgr_sensitive_key' : ['keymgr_dpe.sensitive_key'],

      // The idle connection is automatically connected through topgen.
      // The user does not need to explicitly declare anything other than
      // an empty list.
      'clkmgr.idle'             : [],

      // OTP LC interface
      'otp_ctrl.otp_lc_data'       : ['lc_ctrl.otp_lc_data'],
      'lc_ctrl.lc_otp_program'     : ['otp_ctrl.lc_otp_program'],
      'lc_ctrl.lc_otp_vendor_test' : ['otp_macro.test'],
//      'lc_ctrl.lc_otp_vendor_test' : ['otp_ctrl.lc_otp_vendor_test'],

      // Diversification constant coming from life cycle
      'lc_ctrl.lc_keymgr_div'  : ['keymgr_dpe.lc_keymgr_div'],

      // Strap enable override signal, only used when SecVolatileRawUnlockEn = 1.
      'lc_ctrl.strap_en_override'  : ['rv_dm.strap_en_override'],

      // LC function control signal broadcast
      'lc_ctrl.lc_raw_test_rma'    : ['soc_dbg_ctrl.lc_raw_test_rma']
      'lc_ctrl.lc_dft_en'          : ['otp_macro.lc_dft_en',
                                      'ast.lc_dft_en',
                                      'pwrmgr.lc_dft_en',
                                      'soc_dbg_ctrl.lc_dft_en',
                                      'rv_dm.lc_dft_en'
                                     ],
      'lc_ctrl.lc_hw_debug_clr'    : ['rv_dm.lc_hw_debug_clr'],
      'lc_ctrl.lc_init_done'       : ['rv_dm.lc_init_done'],
      'lc_ctrl.lc_hw_debug_en'     : ['sram_ctrl_main.lc_hw_debug_en',
                                      'ast.lc_hw_debug_en',
                                      'csrng.lc_hw_debug_en',
                                      'rv_dm.lc_hw_debug_en',
                                      'pwrmgr.lc_hw_debug_en',
                                      'soc_dbg_ctrl.lc_hw_debug_en'],
      'lc_ctrl.lc_cpu_en'          : ['rv_core_ibex.lc_cpu_en',
                                      'soc_dbg_ctrl.lc_cpu_en'],
      'lc_ctrl.lc_keymgr_en'       : ['keymgr_dpe.lc_keymgr_en'],
      'lc_ctrl.lc_escalate_en'     : ['aes.lc_escalate_en',
                                      'kmac.lc_escalate_en',
                                      'otbn.lc_escalate_en',
                                      'otp_ctrl.lc_escalate_en',
                                      'sram_ctrl_main.lc_escalate_en',
                                      'sram_ctrl_ret.lc_escalate_en',
                                      'sram_ctrl_mbox.lc_escalate_en',
                                      'aon_timer.lc_escalate_en',
                                      'rv_dm.lc_escalate_en'],

      'lc_ctrl.lc_check_byp_en'    : ['otp_ctrl.lc_check_byp_en',
                                      'rv_dm.lc_check_byp_en'],

      // Darjeeling does not have bypassable clocks. Therefore always ack are req
      'lc_ctrl.lc_clk_byp_ack'     : ['lc_ctrl.lc_clk_byp_req'],

      // LC access control signal broadcast
      'lc_ctrl.lc_creator_seed_sw_rw_en'   : ['otp_ctrl.lc_creator_seed_sw_rw_en'],
      'lc_ctrl.lc_owner_seed_sw_rw_en'     : ['otp_ctrl.lc_owner_seed_sw_rw_en'],
      'lc_ctrl.lc_seed_hw_rd_en'           : ['otp_ctrl.lc_seed_hw_rd_en'],
      'lc_ctrl.lc_rma_state'               : ['otp_ctrl.lc_rma_state',
                                              'soc_dbg_ctrl.lc_rma_state'],

      // OTP PRIM_OTP connections
      'otp_ctrl.otp_macro'         : ['otp_macro.otp'],

      // rv_plic connections
      'rv_plic.msip' : ['rv_core_ibex.irq_software'],
      'rv_plic.irq'  : ['rv_core_ibex.irq_external'],

      // rv_dm connections
      'rv_dm.debug_req': ['rv_core_ibex.debug_req'],

      // rv_timer connections


      // rv core ibex connections
      'rv_core_ibex.crash_dump' : ['rstmgr.cpu_dump'],
      'rv_core_ibex.pwrmgr'     : ['pwrmgr.pwr_cpu'],

      // spi passthrough connection
      'spi_device.passthrough'     : ['spi_host0.passthrough']

      // Debug module reset request to power manager
      'rv_dm.ndmreset_req' : ['pwrmgr.ndmreset_req'],

      // Reset manager software reset request to pwrmgr
      'rstmgr.sw_rst_req' : ['pwrmgr.sw_rst_req'],

      // SOC Proxy TLUL Muxing
      'soc_proxy.dma_tl_h2d' : ['dma.ctn_tl_h2d']
      'soc_proxy.dma_tl_d2h' : ['dma.ctn_tl_d2h']

      'soc_proxy.ctn_tl_h2d' : ['ac_range_check.ctn_tl_h2d']
      'soc_proxy.ctn_tl_d2h' : ['ac_range_check.ctn_tl_d2h']
    }

    // top is to connect to top net/struct.
    // It defines the signal in the top and connect from the module,
    // use of the signal is up to top template
    'top': [
        // top level net for clocks
        'clkmgr.clocks',

        // top level clock gating indications for alert subsystem
        'clkmgr.cg_en',

        // top level net for reset
        'rstmgr.resets',

        // top level reset asserted indications for alert subsystem
        'rstmgr.rst_en',

        // dedicated timer interrupt
        'rv_core_ibex.irq_timer',

        // hardwired connections
        'rv_core_ibex.hart_id', 'rv_core_ibex.boot_addr',

        // Xbars

        // OTP HW_CFG Broadcast signals.
        // TODO(#6713): The actual struct breakout and mapping currently needs to
        // be performed by hand in the toplevel template.
        'otp_ctrl.otp_broadcast',
        'soc_dbg_ctrl.soc_dbg_state',
        'lc_ctrl.otp_device_id',
        'lc_ctrl.otp_manuf_state',
        'keymgr_dpe.device_id',
        'sram_ctrl_main.otp_en_sram_ifetch',
        # Unconditionally disable the late debug feature and enable early debug
        'rv_dm.otp_dis_rv_dm_late_debug'
    ],

    // ext is to create port in the top.
    'external': {
        'ast.lc_dft_en'                        : '',
        'ast.lc_hw_debug_en'                   : '',
        'ast.obs_ctrl'                         : 'obs_ctrl',
        'otbn.ram_cfg_imem'                    : 'otbn_imem_ram_cfg',
        'otbn.ram_cfg_dmem'                    : 'otbn_dmem_ram_cfg',
        'i2c0.ram_cfg'                         : 'i2c0_ram_cfg',
        'rv_core_ibex.ram_cfg_icache_tag'      : 'rv_core_ibex_icache_tag_ram_cfg',
        'rv_core_ibex.ram_cfg_icache_data'     : 'rv_core_ibex_icache_data_ram_cfg',
        'spi_device.ram_cfg_sys2spi'           : 'spi_device_sys2spi_ram_cfg',
        'spi_device.ram_cfg_spi2sys'           : 'spi_device_spi2sys_ram_cfg',
        'rom_ctrl0.rom_cfg'                    : 'rom_ctrl0_rom_cfg',
        'rom_ctrl1.rom_cfg'                    : 'rom_ctrl1_rom_cfg',
        'sram_ctrl_main.ram_cfg'               : 'sram_ctrl_main_ram_cfg',
        'sram_ctrl_ret.ram_cfg'                : 'sram_ctrl_ret_ram_cfg',
        'sram_ctrl_mbox.ram_cfg'               : 'sram_ctrl_mbox_ram_cfg',
        'pwrmgr.boot_status'                   : 'pwrmgr_boot_status_obs',
        'pwrmgr.ext_rst_ack'                   : 'pwrmgr_ext_rst_ack',
        'clkmgr.clocks'                        : '',
        'clkmgr.cg_en'                         : '',
        'clkmgr.jitter_en'                     : 'clk_main_jitter_en',
        'dma.sys'                              : 'dma_sys',
        'entropy_src.entropy_src_rng_enable'   : 'es_rng_enable',
        'entropy_src.entropy_src_rng_valid'    : 'es_rng_valid',
        'entropy_src.entropy_src_rng_bits'     : 'es_rng_bit',
        'entropy_src.rng_fips'                 : 'es_rng_fips',
        'mbx.tl_mbx'                           : 'mbx_tl',
        'mbx0.doe_intr'                        : 'mbx0_doe_intr',
        'mbx0.doe_intr_en'                     : 'mbx0_doe_intr_en',
        'mbx0.doe_intr_support'                : 'mbx0_doe_intr_support',
        'mbx0.doe_async_msg_support'           : 'mbx0_doe_async_msg_support',
        'mbx1.doe_intr'                        : 'mbx1_doe_intr',
        'mbx1.doe_intr_en'                     : 'mbx1_doe_intr_en',
        'mbx1.doe_intr_support'                : 'mbx1_doe_intr_support',
        'mbx1.doe_async_msg_support'           : 'mbx1_doe_async_msg_support',
        'mbx2.doe_intr'                        : 'mbx2_doe_intr',
        'mbx2.doe_intr_en'                     : 'mbx2_doe_intr_en',
        'mbx2.doe_intr_support'                : 'mbx2_doe_intr_support',
        'mbx2.doe_async_msg_support'           : 'mbx2_doe_async_msg_support',
        'mbx3.doe_intr'                        : 'mbx3_doe_intr',
        'mbx3.doe_intr_en'                     : 'mbx3_doe_intr_en',
        'mbx3.doe_intr_support'                : 'mbx3_doe_intr_support',
        'mbx3.doe_async_msg_support'           : 'mbx3_doe_async_msg_support',
        'mbx4.doe_intr'                        : 'mbx4_doe_intr',
        'mbx4.doe_intr_en'                     : 'mbx4_doe_intr_en',
        'mbx4.doe_intr_support'                : 'mbx4_doe_intr_support',
        'mbx4.doe_async_msg_support'           : 'mbx4_doe_async_msg_support',
        'mbx5.doe_intr'                        : 'mbx5_doe_intr',
        'mbx5.doe_intr_en'                     : 'mbx5_doe_intr_en',
        'mbx5.doe_intr_support'                : 'mbx5_doe_intr_support',
        'mbx5.doe_async_msg_support'           : 'mbx5_doe_async_msg_support',
        'mbx6.doe_intr'                        : 'mbx6_doe_intr',
        'mbx6.doe_intr_en'                     : 'mbx6_doe_intr_en',
        'mbx6.doe_intr_support'                : 'mbx6_doe_intr_support',
        'mbx6.doe_async_msg_support'           : 'mbx6_doe_async_msg_support',
        'mbx_jtag.doe_intr'                    : 'mbx_jtag_doe_intr',
        'mbx_jtag.doe_intr_en'                 : 'mbx_jtag_doe_intr_en',
        'mbx_jtag.doe_intr_support'            : 'mbx_jtag_doe_intr_support',
        'mbx_jtag.doe_async_msg_support'       : 'mbx_jtag_doe_async_msg_support',
        'mbx_pcie0.doe_intr'                   : 'mbx_pcie0_doe_intr',
        'mbx_pcie0.doe_intr_en'                : 'mbx_pcie0_doe_intr_en',
        'mbx_pcie0.doe_intr_support'           : 'mbx_pcie0_doe_intr_support',
        'mbx_pcie0.doe_async_msg_support'      : 'mbx_pcie0_doe_async_msg_support',
        'mbx_pcie1.doe_intr'                   : 'mbx_pcie1_doe_intr',
        'mbx_pcie1.doe_intr_en'                : 'mbx_pcie1_doe_intr_en',
        'mbx_pcie1.doe_intr_support'           : 'mbx_pcie1_doe_intr_support',
        'mbx_pcie1.doe_async_msg_support'      : 'mbx_pcie1_doe_async_msg_support',
        'dbg.tl_dbg'                           : 'dbg_tl',
        'rv_dm.next_dm_addr'                   : 'rv_dm_next_dm_addr',
        'peri.tl_ast'                          : 'ast_tl',
        'pwrmgr.pwr_ast'                       : 'pwrmgr_ast',
        'otp_macro.pwr_seq'                    : '',
        'otp_macro.pwr_seq_h'                  : '',
        'otp_macro.ext_voltage_h'              : 'otp_ext_voltage_h',
        'otp_macro.otp_obs'                    : 'otp_obs',
        'otp_macro.cfg'                        : 'otp_cfg',
        'rstmgr.por_n'                         : 'por_n',
        'rstmgr.resets'                        : '',
        'rstmgr.rst_en'                        : '',
        'soc_proxy.misc_tl_h2d'                : 'ctn_misc_tl_h2d',
        'soc_proxy.misc_tl_d2h'                : 'ctn_misc_tl_d2h',
        'soc_proxy.soc_wkup_async'             : 'soc_wkup_async',
        'soc_proxy.soc_rst_req_async'          : 'soc_rst_req_async',
        'soc_proxy.soc_lsio_trigger'           : 'soc_lsio_trigger',
        'soc_proxy.soc_gpi_async'              : 'soc_gpi_async',
        'soc_proxy.soc_gpo_async'              : 'soc_gpo_async',
        'soc_proxy.integrator_id'              : 'integrator_id',
        'spi_device.sck_monitor'               : 'sck_monitor',
        'soc_dbg_ctrl.soc_dbg_policy_bus'      : 'soc_dbg_policy_bus',
        'soc_dbg_ctrl.halt_cpu_boot'           : 'debug_halt_cpu_boot',
        'racl_ctrl.racl_policies'              : 'racl_policies',
        'racl_ctrl.racl_error_external'        : 'racl_error',
        'ac_range_check.range_check_overwrite' : 'ac_range_check_overwrite',
        'ac_range_check.ctn_filtered_tl_h2d'   : 'ctn_tl_h2d',
        'ac_range_check.ctn_filtered_tl_d2h'   : 'ctn_tl_d2h'
    },
  },

  // Crossbars: having a top level crossbar
  // This version assumes all crossbars are instantiated at the top.
  // Assume xbar.hjson is located in the same directory of top.hjson
  xbar: [
    { name: "main",
      clock_srcs: {clk_main_i: "main",
                   clk_fixed_i: "io"},
      clock_group: "infra",
      reset: "lc",
      reset_connections: {rst_main_ni: "lc",
                          rst_fixed_ni: "lc_io"}
    },
    { name: "peri",
      clock_srcs: {clk_peri_i: "io", },
      clock_group: "infra",
      reset: "lc_io",
      reset_connections: {rst_peri_ni: "lc_io"},
    },
    { name: "mbx",
      clock_srcs: {clk_mbx_i: "main"},
      clock_group: "infra",
      reset: "lc",
      reset_connections: {rst_mbx_ni: "lc"},
    },
    { name: "dbg",
      clock_srcs: {clk_dbg_i: "main", clk_peri_i: "io"},
      clock_group: "infra",
      reset: "lc",
      reset_connections: {rst_dbg_ni: "lc", rst_peri_ni: "lc_io"},
    },
  ],

  // ===== PINMUX & PINOUT ======================================================

  pinout: {
    // IO power bank declaration.
    // This list defines the IO bank power domains on the ASIC.
    // Each individual pad must be in one of the declared power domains.
    banks: ['VIO'],
    // Pad declaration.
    // Each entry must have the following four keys:
    //
    // - name: Name of the pad (this will be exposed at the chiplevel).
    //
    // - type: Pad type (this maps to the pad types defined in prim_pad_wrapper_pkg.sv)
    //
    // - bank: Specifies in which of the IO power banks this pad lives.
    //
    // - connection: Can have either of the following values:
    //
    //               1) 'direct': This is a dedicated IO Pad that is directly connected to a peripheral.
    //
    //               2) 'manual': This is a dedicated IO signal that is not directly connected to a
    //                            peripheral. It needs to be manually wired up in the template.
    //
    //               3) 'muxed': This is a muxed IO pad that will be connected to the pinmux.
    //
    // Optionally, each pad can also have the following keys:
    //
    // - desc: A field for further description.
    //
    // - port_type: A field to override the default 'inout wire' type (this is currently only used
    //              for simulating ADC connections where the ports have to be switched to a real
    //              type when the ANALOGSIM macro is defined).
    //
    // Muxed and direct pads may also have:
    //
    // - attrs: This field allows to define the reset values of the MIO/DIO_PAD_ATTR CSR of direct
    //          or muxed pads. It is a dict mapping CSR field names to integer reset values. An
    //          example is: `attrs: {virtual_od_en: 1, drive_strength: 3}`
    //
    //          Fields not specified keep the default reset value of the pinmux. Whether a pad
    //          supports an attribute depends on its type and technology (WARL).
    pads: [
      // Special manually connected pads
      { name: 'POR_N'           , type: 'InputStd',     bank: 'VIO' , connection: 'manual', desc: 'System reset'},
      { name: 'JTAG_TCK'        , type: 'InputStd',     bank: 'VIO' , connection: 'manual', desc: 'JTAG TCK signal'},
      { name: 'JTAG_TMS'        , type: 'InputStd',     bank: 'VIO' , connection: 'manual', desc: 'JTAG TMS signal'},
      { name: 'JTAG_TDI'        , type: 'InputStd',     bank: 'VIO' , connection: 'manual', desc: 'JTAG TDI signal'},
      { name: 'JTAG_TDO'        , type: 'BidirStd',     bank: 'VIO' , connection: 'manual', desc: 'JTAG TDO signal'},
      { name: 'JTAG_TRST_N'     , type: 'InputStd',     bank: 'VIO' , connection: 'manual', desc: 'JTAG TRST_N signal'},
      { name: 'OTP_EXT_VOLT'    , type: 'AnalogIn1',    bank: 'VIO' , connection: 'manual', desc: 'OTP external voltage input'},
      // Dedicated IOs
      { name: 'SPI_HOST_D0'     , type: 'BidirStd', bank: 'VIO', connection: 'direct', desc: 'SPI host data'},
      { name: 'SPI_HOST_D1'     , type: 'BidirStd', bank: 'VIO', connection: 'direct', desc: 'SPI host data'},
      { name: 'SPI_HOST_D2'     , type: 'BidirStd', bank: 'VIO', connection: 'direct', desc: 'SPI host data'},
      { name: 'SPI_HOST_D3'     , type: 'BidirStd', bank: 'VIO', connection: 'direct', desc: 'SPI host data'},
      { name: 'SPI_HOST_CLK'    , type: 'BidirStd', bank: 'VIO', connection: 'direct', desc: 'SPI host clock'},
      { name: 'SPI_HOST_CS_L'   , type: 'BidirStd', bank: 'VIO', connection: 'direct', desc: 'SPI host chip select'},
      { name: 'SPI_DEV_D0'      , type: 'BidirStd', bank: 'VIO', connection: 'direct', desc: 'SPI device data'},
      { name: 'SPI_DEV_D1'      , type: 'BidirStd', bank: 'VIO', connection: 'direct', desc: 'SPI device data'},
      { name: 'SPI_DEV_D2'      , type: 'BidirStd', bank: 'VIO', connection: 'direct', desc: 'SPI device data'},
      { name: 'SPI_DEV_D3'      , type: 'BidirStd', bank: 'VIO', connection: 'direct', desc: 'SPI device data'},
      { name: 'SPI_DEV_CLK'     , type: 'InputStd', bank: 'VIO', connection: 'direct', desc: 'SPI device clock'},
      { name: 'SPI_DEV_CS_L'    , type: 'InputStd', bank: 'VIO', connection: 'direct', desc: 'SPI device chip select'},
      { name: 'SPI_DEV_TPM_CS_L', type: 'InputStd', bank: 'VIO', connection: 'direct', desc: 'SPI device TPM chip select'},
      { name: 'UART_RX'         , type: 'InputStd', bank: 'VIO', connection: 'direct', desc: 'UART receive'},
      { name: 'UART_TX'         , type: 'BidirStd', bank: 'VIO', connection: 'direct', desc: 'UART transmit'},
      { name: 'I2C_SCL'         , type: 'BidirStd', bank: 'VIO', connection: 'direct', desc: 'I2C clock'},
      { name: 'I2C_SDA'         , type: 'BidirStd', bank: 'VIO', connection: 'direct', desc: 'I2C data'},
      // RoT GPIO
      { name: 'GPIO0'           , type: 'BidirStd', bank: 'VIO', connection: 'direct', desc: 'GPIO pad'},
      { name: 'GPIO1'           , type: 'BidirStd', bank: 'VIO', connection: 'direct', desc: 'GPIO pad'},
      { name: 'GPIO2'           , type: 'BidirStd', bank: 'VIO', connection: 'direct', desc: 'GPIO pad'},
      { name: 'GPIO3'           , type: 'BidirStd', bank: 'VIO', connection: 'direct', desc: 'GPIO pad'},
      { name: 'GPIO4'           , type: 'BidirStd', bank: 'VIO', connection: 'direct', desc: 'GPIO pad'},
      { name: 'GPIO5'           , type: 'BidirStd', bank: 'VIO', connection: 'direct', desc: 'GPIO pad'},
      { name: 'GPIO6'           , type: 'BidirStd', bank: 'VIO', connection: 'direct', desc: 'GPIO pad'},
      { name: 'GPIO7'           , type: 'BidirStd', bank: 'VIO', connection: 'direct', desc: 'GPIO pad'},
      { name: 'GPIO8'           , type: 'BidirStd', bank: 'VIO', connection: 'direct', desc: 'GPIO pad'},
      { name: 'GPIO9'           , type: 'BidirStd', bank: 'VIO', connection: 'direct', desc: 'GPIO pad'},
      { name: 'GPIO10'          , type: 'BidirStd', bank: 'VIO', connection: 'direct', desc: 'GPIO pad'},
      { name: 'GPIO11'          , type: 'BidirStd', bank: 'VIO', connection: 'direct', desc: 'GPIO pad'},
      { name: 'GPIO12'          , type: 'BidirStd', bank: 'VIO', connection: 'direct', desc: 'GPIO pad'},
      { name: 'GPIO13'          , type: 'BidirStd', bank: 'VIO', connection: 'direct', desc: 'GPIO pad'},
      { name: 'GPIO14'          , type: 'BidirStd', bank: 'VIO', connection: 'direct', desc: 'GPIO pad'},
      { name: 'GPIO15'          , type: 'BidirStd', bank: 'VIO', connection: 'direct', desc: 'GPIO pad'},
      { name: 'GPIO16'          , type: 'BidirStd', bank: 'VIO', connection: 'direct', desc: 'GPIO pad'},
      { name: 'GPIO17'          , type: 'BidirStd', bank: 'VIO', connection: 'direct', desc: 'GPIO pad'},
      { name: 'GPIO18'          , type: 'BidirStd', bank: 'VIO', connection: 'direct', desc: 'GPIO pad'},
      { name: 'GPIO19'          , type: 'BidirStd', bank: 'VIO', connection: 'direct', desc: 'GPIO pad'},
      { name: 'GPIO20'          , type: 'BidirStd', bank: 'VIO', connection: 'direct', desc: 'GPIO pad'},
      { name: 'GPIO21'          , type: 'BidirStd', bank: 'VIO', connection: 'direct', desc: 'GPIO pad'},
      { name: 'GPIO22'          , type: 'BidirStd', bank: 'VIO', connection: 'direct', desc: 'GPIO pad'},
      { name: 'GPIO23'          , type: 'BidirStd', bank: 'VIO', connection: 'direct', desc: 'GPIO pad'},
      { name: 'GPIO24'          , type: 'BidirStd', bank: 'VIO', connection: 'direct', desc: 'GPIO pad'},
      { name: 'GPIO25'          , type: 'BidirStd', bank: 'VIO', connection: 'direct', desc: 'GPIO pad'},
      { name: 'GPIO26'          , type: 'BidirStd', bank: 'VIO', connection: 'direct', desc: 'GPIO pad'},
      { name: 'GPIO27'          , type: 'BidirStd', bank: 'VIO', connection: 'direct', desc: 'GPIO pad'},
      { name: 'GPIO28'          , type: 'BidirStd', bank: 'VIO', connection: 'direct', desc: 'GPIO pad'},
      { name: 'GPIO29'          , type: 'BidirStd', bank: 'VIO', connection: 'direct', desc: 'GPIO pad'},
      { name: 'GPIO30'          , type: 'BidirStd', bank: 'VIO', connection: 'direct', desc: 'GPIO pad'},
      { name: 'GPIO31'          , type: 'BidirStd', bank: 'VIO', connection: 'direct', desc: 'GPIO pad'},
      // SOC GPIO
      { name: 'SOC_GPI0'        , type: 'InputStd', bank: 'VIO', connection: 'direct', desc: 'SoC general purpose input'},
      { name: 'SOC_GPI1'        , type: 'InputStd', bank: 'VIO', connection: 'direct', desc: 'SoC general purpose input'},
      { name: 'SOC_GPI2'        , type: 'InputStd', bank: 'VIO', connection: 'direct', desc: 'SoC general purpose input'},
      { name: 'SOC_GPI3'        , type: 'InputStd', bank: 'VIO', connection: 'direct', desc: 'SoC general purpose input'},
      { name: 'SOC_GPI4'        , type: 'InputStd', bank: 'VIO', connection: 'direct', desc: 'SoC general purpose input'},
      { name: 'SOC_GPI5'        , type: 'InputStd', bank: 'VIO', connection: 'direct', desc: 'SoC general purpose input'},
      { name: 'SOC_GPI6'        , type: 'InputStd', bank: 'VIO', connection: 'direct', desc: 'SoC general purpose input'},
      { name: 'SOC_GPI7'        , type: 'InputStd', bank: 'VIO', connection: 'direct', desc: 'SoC general purpose input'},
      { name: 'SOC_GPI8'        , type: 'InputStd', bank: 'VIO', connection: 'direct', desc: 'SoC general purpose input'},
      { name: 'SOC_GPI9'        , type: 'InputStd', bank: 'VIO', connection: 'direct', desc: 'SoC general purpose input'},
      { name: 'SOC_GPI10'       , type: 'InputStd', bank: 'VIO', connection: 'direct', desc: 'SoC general purpose input'},
      { name: 'SOC_GPI11'       , type: 'InputStd', bank: 'VIO', connection: 'direct', desc: 'SoC general purpose input'},
      { name: 'SOC_GPO0'        , type: 'BidirStd', bank: 'VIO', connection: 'direct', desc: 'SoC general purpose output'},
      { name: 'SOC_GPO1'        , type: 'BidirStd', bank: 'VIO', connection: 'direct', desc: 'SoC general purpose output'},
      { name: 'SOC_GPO2'        , type: 'BidirStd', bank: 'VIO', connection: 'direct', desc: 'SoC general purpose output'},
      { name: 'SOC_GPO3'        , type: 'BidirStd', bank: 'VIO', connection: 'direct', desc: 'SoC general purpose output'},
      { name: 'SOC_GPO4'        , type: 'BidirStd', bank: 'VIO', connection: 'direct', desc: 'SoC general purpose output'},
      { name: 'SOC_GPO5'        , type: 'BidirStd', bank: 'VIO', connection: 'direct', desc: 'SoC general purpose output'},
      { name: 'SOC_GPO6'        , type: 'BidirStd', bank: 'VIO', connection: 'direct', desc: 'SoC general purpose output'},
      { name: 'SOC_GPO7'        , type: 'BidirStd', bank: 'VIO', connection: 'direct', desc: 'SoC general purpose output'},
      { name: 'SOC_GPO8'        , type: 'BidirStd', bank: 'VIO', connection: 'direct', desc: 'SoC general purpose output'},
      { name: 'SOC_GPO9'        , type: 'BidirStd', bank: 'VIO', connection: 'direct', desc: 'SoC general purpose output'},
      { name: 'SOC_GPO10'       , type: 'BidirStd', bank: 'VIO', connection: 'direct', desc: 'SoC general purpose output'},
      { name: 'SOC_GPO11'       , type: 'BidirStd', bank: 'VIO', connection: 'direct', desc: 'SoC general purpose output'},
      // Muxed pads
      { name: 'MIO0'            , type: 'BidirStd', bank: 'VIO', connection: 'muxed' , desc: 'Muxed IO pad'},
      { name: 'MIO1'            , type: 'BidirStd', bank: 'VIO', connection: 'muxed' , desc: 'Muxed IO pad'},
      { name: 'MIO2'            , type: 'BidirStd', bank: 'VIO', connection: 'muxed' , desc: 'Muxed IO pad'},
      { name: 'MIO3'            , type: 'BidirStd', bank: 'VIO', connection: 'muxed' , desc: 'Muxed IO pad'},
      { name: 'MIO4'            , type: 'BidirStd', bank: 'VIO', connection: 'muxed' , desc: 'Muxed IO pad'},
      { name: 'MIO5'            , type: 'BidirStd', bank: 'VIO', connection: 'muxed' , desc: 'Muxed IO pad'},
      { name: 'MIO6'            , type: 'BidirStd', bank: 'VIO', connection: 'muxed' , desc: 'Muxed IO pad'},
      { name: 'MIO7'            , type: 'BidirStd', bank: 'VIO', connection: 'muxed' , desc: 'Muxed IO pad'},
      { name: 'MIO8'            , type: 'BidirStd', bank: 'VIO', connection: 'muxed' , desc: 'Muxed IO pad'},
      { name: 'MIO9'            , type: 'BidirStd', bank: 'VIO', connection: 'muxed' , desc: 'Muxed IO pad'},
      { name: 'MIO10'           , type: 'BidirStd', bank: 'VIO', connection: 'muxed' , desc: 'Muxed IO pad'},
      { name: 'MIO11'           , type: 'BidirStd', bank: 'VIO', connection: 'muxed' , desc: 'Muxed IO pad'},
    ]
  }

  pinmux: {
    // Signal to pinmux/pad mapping.
    // Each entry in the list below must have the following three mandatory keys:
    //
    // - instance: This is the comportable IO instance name where the IO signal comes from.
    //
    // - connection: This key is similar to the connection key in the pinout/pad configuration and
    //               can have either of the following values:
    //
    //               1) 'direct': This is a dedicated IO signal that is directly connected to a pad.
    //                            Such an IO signal must also specify the 'port' key and exactly
    //                            one pad in 'pads' (see further below).
    //
    //               2) 'manual': This is a dedicated IO signal that is not directly connected to a pad.
    //                            It needs to be manually wired up in the template.
    //                            Such an IO signal may have a 'port' key and must have an empty
    //                            'pads'.
    //
    //               3) 'muxed': This is a muxed IO signal that will be connected to the pinmux.
    //                           Such an IO signal may have a 'port' key.
    //
    // - pads: Required list of pad names. The content depends on the connection type:
    //         direct: Exactly one entry, the direct pad this signal is connected to.
    //         manual: No meaning. Must be an empty list.
    //         muxed:  Restricts the muxing to the listed muxed pads. An empty list means that the
    //                 signal can be muxed to all muxed pads and all pads can be muxed to this
    //                 signal. The muxing constraint also depends on the direction of the signal:
    //                 - Input:  defines the pads this signal can select (INSEL).
    //                 - Output: defines the pads that can select this signal (OUTSEL).
    //                 - Inout:  defines both directions at once.
    //
    //                 If 'port' is empty, the list applies to all ports of the instance.
    //
    // Depending on the connection type specified, each entry may have the following optional keys:
    //
    // - port: Name of the available IO signal of the instance.
    //         This is required for 'direct' connections, but optional for the others.
    //         Individual signals of a bus IO signal must be indexed with square brackets, e.g. mybus[1].
    //         Not specifying this key or setting it to an empty string acts as a wild card
    //         and includes all available IOs of this instance.
    //
    // - default: Defines the muxing at reset of a muxed signal, i.e., the reset values of the INSEL
    //            and OUTSEL registers. Only muxed connections may have this key. The possible
    //            values depend on the signal direction:
    //
    //            If input:  Defines the INSEL reset value for this signal. Possible defaults are:
    //                       - a pad name (string): Signal is connected to this pad at reset.
    //                       - 0 or 1 (int):        Signal is driven to '0 or '1 at reset.
    //
    //                       If default is not specified, the signal is driven to '0.
    //
    //            If output: The value must be a pad name. If given, this pad is then driven by
    //                       this signal after reset (defines the OUTSEL reset value for this pad).
    //                       Each pad may only be referenced once in the complete 'signals' list as
    //                       a default pad.
    //
    //                       If a pad is never specified as a default, the pad is set to high-Z at
    //                       reset.
    //
    //            If inout:  Defines the INSEL and OUTSEL reset values for this signal and pad.
    //                       Possible defaults are:
    //                       - a pad name (string): Signal is connected to this pad at reset and the
    //                                              pad's default output is this signal.
    //                       - 0 or 1 (int):        Signal is driven to '0 or '1 at reset. Imposes
    //                                              no default source for any pad.
    //
    //                       If this default is not specified, the signal is driven to '0 and no pad
    //                       default is derived.
    //
    // - follower: Only allowed for muxed 1-bit input or bidir signals. A string naming another
    //             comportable input which is controlled by the same INSEL CSR, decoded as
    //             'instance.port'. The follower must always be a 1-bit input and must not have
    //             its own signal entry. It gets no INSEL CSR of its own.
    //
    //             This allows controlling with one INSEL CSR the muxing of signals which go to
    //             different IPs or partitions of an IP. Examples are the reset detector signals
    //             for I3C. These must always follow SCL/SDA and the muxing must also be active in
    //             deep sleep. Defining the reset detector signals as followers of SCL/SDA ensures
    //             they always stay in sync. It also ensures that the muxing is active in deep
    //             sleep as in this particular case the muxing is duplicated in both pinmux
    //             partitions.
    //
    //             An empty string generates the INSEL mux of this signal in both partitions, so
    //             both partitions provide the mux result. This is useful when directly tapping
    //             into the mux results, see for example the USB wakeup detector inside the
    //             pinmux.
    //
    // - desc: Optional description field.
    //
    // - attr: Manual direct IOs may specify an additional pad attr field.
    //         This is used to create the correct pad attribute CSR for that DIO channel (since the
    //         DIO is manual, there is no way to automatically infer the corresponding pad type).
    //         Not to be confused with the 'attrs' key of a pad.
    //
    signals: [
      // SPI Host0
      { instance: 'spi_host0',       port: 'sck',            connection: 'direct', pads: ['SPI_HOST_CLK']     , desc: ''},
      { instance: 'spi_host0',       port: 'csb',            connection: 'direct', pads: ['SPI_HOST_CS_L']    , desc: ''},
      { instance: 'spi_host0',       port: 'sd[0]',          connection: 'direct', pads: ['SPI_HOST_D0']      , desc: ''},
      { instance: 'spi_host0',       port: 'sd[1]',          connection: 'direct', pads: ['SPI_HOST_D1']      , desc: ''},
      { instance: 'spi_host0',       port: 'sd[2]',          connection: 'direct', pads: ['SPI_HOST_D2']      , desc: ''},
      { instance: 'spi_host0',       port: 'sd[3]',          connection: 'direct', pads: ['SPI_HOST_D3']      , desc: ''},
      // SPI Device
      { instance: 'spi_device',      port: 'sck',            connection: 'direct', pads: ['SPI_DEV_CLK']      , desc: ''},
      { instance: 'spi_device',      port: 'csb',            connection: 'direct', pads: ['SPI_DEV_CS_L']     , desc: ''},
      { instance: 'spi_device',      port: 'sd[0]',          connection: 'direct', pads: ['SPI_DEV_D0']       , desc: ''},
      { instance: 'spi_device',      port: 'sd[1]',          connection: 'direct', pads: ['SPI_DEV_D1']       , desc: ''},
      { instance: 'spi_device',      port: 'sd[2]',          connection: 'direct', pads: ['SPI_DEV_D2']       , desc: ''},
      { instance: 'spi_device',      port: 'sd[3]',          connection: 'direct', pads: ['SPI_DEV_D3']       , desc: ''},
      { instance: "spi_device",      port: 'tpm_csb',        connection: 'direct', pads: ['SPI_DEV_TPM_CS_L'] , desc: ''},
      // UART
      { instance: "uart0",           port: 'rx',             connection: 'direct', pads: ['UART_RX']          , desc: ''},
      { instance: "uart0",           port: 'tx',             connection: 'direct', pads: ['UART_TX']          , desc: ''},
      // I2C
      { instance: "i2c0",            port: 'scl',            connection: 'direct', pads: ['I2C_SCL']          , desc: ''},
      { instance: "i2c0",            port: 'sda',            connection: 'direct', pads: ['I2C_SDA']          , desc: ''},
      // RoT GPIO
      { instance: "gpio0",           port: 'gpio[0]',        connection: 'direct', pads: ['GPIO0']            , desc: ''},
      { instance: "gpio0",           port: 'gpio[1]',        connection: 'direct', pads: ['GPIO1']            , desc: ''},
      { instance: "gpio0",           port: 'gpio[2]',        connection: 'direct', pads: ['GPIO2']            , desc: ''},
      { instance: "gpio0",           port: 'gpio[3]',        connection: 'direct', pads: ['GPIO3']            , desc: ''},
      { instance: "gpio0",           port: 'gpio[4]',        connection: 'direct', pads: ['GPIO4']            , desc: ''},
      { instance: "gpio0",           port: 'gpio[5]',        connection: 'direct', pads: ['GPIO5']            , desc: ''},
      { instance: "gpio0",           port: 'gpio[6]',        connection: 'direct', pads: ['GPIO6']            , desc: ''},
      { instance: "gpio0",           port: 'gpio[7]',        connection: 'direct', pads: ['GPIO7']            , desc: ''},
      { instance: "gpio0",           port: 'gpio[8]',        connection: 'direct', pads: ['GPIO8']            , desc: ''},
      { instance: "gpio0",           port: 'gpio[9]',        connection: 'direct', pads: ['GPIO9']            , desc: ''},
      { instance: "gpio0",           port: 'gpio[10]',       connection: 'direct', pads: ['GPIO10']           , desc: ''},
      { instance: "gpio0",           port: 'gpio[11]',       connection: 'direct', pads: ['GPIO11']           , desc: ''},
      { instance: "gpio0",           port: 'gpio[12]',       connection: 'direct', pads: ['GPIO12']           , desc: ''},
      { instance: "gpio0",           port: 'gpio[13]',       connection: 'direct', pads: ['GPIO13']           , desc: ''},
      { instance: "gpio0",           port: 'gpio[14]',       connection: 'direct', pads: ['GPIO14']           , desc: ''},
      { instance: "gpio0",           port: 'gpio[15]',       connection: 'direct', pads: ['GPIO15']           , desc: ''},
      { instance: "gpio0",           port: 'gpio[16]',       connection: 'direct', pads: ['GPIO16']           , desc: ''},
      { instance: "gpio0",           port: 'gpio[17]',       connection: 'direct', pads: ['GPIO17']           , desc: ''},
      { instance: "gpio0",           port: 'gpio[18]',       connection: 'direct', pads: ['GPIO18']           , desc: ''},
      { instance: "gpio0",           port: 'gpio[19]',       connection: 'direct', pads: ['GPIO19']           , desc: ''},
      { instance: "gpio0",           port: 'gpio[20]',       connection: 'direct', pads: ['GPIO20']           , desc: ''},
      { instance: "gpio0",           port: 'gpio[21]',       connection: 'direct', pads: ['GPIO21']           , desc: ''},
      { instance: "gpio0",           port: 'gpio[22]',       connection: 'direct', pads: ['GPIO22']           , desc: ''},
      { instance: "gpio0",           port: 'gpio[23]',       connection: 'direct', pads: ['GPIO23']           , desc: ''},
      { instance: "gpio0",           port: 'gpio[24]',       connection: 'direct', pads: ['GPIO24']           , desc: ''},
      { instance: "gpio0",           port: 'gpio[25]',       connection: 'direct', pads: ['GPIO25']           , desc: ''},
      { instance: "gpio0",           port: 'gpio[26]',       connection: 'direct', pads: ['GPIO26']           , desc: ''},
      { instance: "gpio0",           port: 'gpio[27]',       connection: 'direct', pads: ['GPIO27']           , desc: ''},
      { instance: "gpio0",           port: 'gpio[28]',       connection: 'direct', pads: ['GPIO28']           , desc: ''},
      { instance: "gpio0",           port: 'gpio[29]',       connection: 'direct', pads: ['GPIO29']           , desc: ''},
      { instance: "gpio0",           port: 'gpio[30]',       connection: 'direct', pads: ['GPIO30']           , desc: ''},
      { instance: "gpio0",           port: 'gpio[31]',       connection: 'direct', pads: ['GPIO31']           , desc: ''},
      // SoC GPIO
      { instance: "soc_proxy",       port: 'soc_gpi[0]',     connection: 'direct', pads: ['SOC_GPI0']         , desc: ''},
      { instance: "soc_proxy",       port: 'soc_gpi[1]',     connection: 'direct', pads: ['SOC_GPI1']         , desc: ''},
      { instance: "soc_proxy",       port: 'soc_gpi[2]',     connection: 'direct', pads: ['SOC_GPI2']         , desc: ''},
      { instance: "soc_proxy",       port: 'soc_gpi[3]',     connection: 'direct', pads: ['SOC_GPI3']         , desc: ''},
      { instance: "soc_proxy",       port: 'soc_gpi[4]',     connection: 'direct', pads: ['SOC_GPI4']         , desc: ''},
      { instance: "soc_proxy",       port: 'soc_gpi[5]',     connection: 'direct', pads: ['SOC_GPI5']         , desc: ''},
      { instance: "soc_proxy",       port: 'soc_gpi[6]',     connection: 'direct', pads: ['SOC_GPI6']         , desc: ''},
      { instance: "soc_proxy",       port: 'soc_gpi[7]',     connection: 'direct', pads: ['SOC_GPI7']         , desc: ''},
      { instance: "soc_proxy",       port: 'soc_gpi[8]',     connection: 'direct', pads: ['SOC_GPI8']         , desc: ''},
      { instance: "soc_proxy",       port: 'soc_gpi[9]',     connection: 'direct', pads: ['SOC_GPI9']         , desc: ''},
      { instance: "soc_proxy",       port: 'soc_gpi[10]',    connection: 'direct', pads: ['SOC_GPI10']        , desc: ''},
      { instance: "soc_proxy",       port: 'soc_gpi[11]',    connection: 'direct', pads: ['SOC_GPI11']        , desc: ''},
      { instance: "soc_proxy",       port: 'soc_gpi[12]',    connection: 'muxed' , pads: []                   , desc: ''},
      { instance: "soc_proxy",       port: 'soc_gpi[13]',    connection: 'muxed' , pads: []                   , desc: ''},
      { instance: "soc_proxy",       port: 'soc_gpi[14]',    connection: 'muxed' , pads: []                   , desc: ''},
      { instance: "soc_proxy",       port: 'soc_gpi[15]',    connection: 'muxed' , pads: []                   , desc: ''},
      { instance: "soc_proxy",       port: 'soc_gpo[0]',     connection: 'direct', pads: ['SOC_GPO0']         , desc: ''},
      { instance: "soc_proxy",       port: 'soc_gpo[1]',     connection: 'direct', pads: ['SOC_GPO1']         , desc: ''},
      { instance: "soc_proxy",       port: 'soc_gpo[2]',     connection: 'direct', pads: ['SOC_GPO2']         , desc: ''},
      { instance: "soc_proxy",       port: 'soc_gpo[3]',     connection: 'direct', pads: ['SOC_GPO3']         , desc: ''},
      { instance: "soc_proxy",       port: 'soc_gpo[4]',     connection: 'direct', pads: ['SOC_GPO4']         , desc: ''},
      { instance: "soc_proxy",       port: 'soc_gpo[5]',     connection: 'direct', pads: ['SOC_GPO5']         , desc: ''},
      { instance: "soc_proxy",       port: 'soc_gpo[6]',     connection: 'direct', pads: ['SOC_GPO6']         , desc: ''},
      { instance: "soc_proxy",       port: 'soc_gpo[7]',     connection: 'direct', pads: ['SOC_GPO7']         , desc: ''},
      { instance: "soc_proxy",       port: 'soc_gpo[8]',     connection: 'direct', pads: ['SOC_GPO8']         , desc: ''},
      { instance: "soc_proxy",       port: 'soc_gpo[9]',     connection: 'direct', pads: ['SOC_GPO9']         , desc: ''},
      { instance: "soc_proxy",       port: 'soc_gpo[10]',    connection: 'direct', pads: ['SOC_GPO10']        , desc: ''},
      { instance: "soc_proxy",       port: 'soc_gpo[11]',    connection: 'direct', pads: ['SOC_GPO11']        , desc: ''},
      { instance: "soc_proxy",       port: 'soc_gpo[12]',    connection: 'muxed' , pads: []                   , desc: ''},
      { instance: "soc_proxy",       port: 'soc_gpo[13]',    connection: 'muxed' , pads: []                   , desc: ''},
      { instance: "soc_proxy",       port: 'soc_gpo[14]',    connection: 'muxed' , pads: []                   , desc: ''},
      { instance: "soc_proxy",       port: 'soc_gpo[15]',    connection: 'muxed' , pads: []                   , desc: ''},
      // Other MIOs
      { instance: "otp_macro",        port: 'test[0]',        connection: 'muxed' , pads: []                  , desc: ''},
    ],

    num_wkup_detect: 8
    wkup_cnt_width:  8
    // Disable USB wakeup and hardware strap sampling for integrated OpenTitan
    enable_usb_wakeup: false
    enable_strap_sampling: false
  }

  // Implementation targets.
  // This defines the configuration of the target-specific chip-levels  to
  // generate from the shared template. Each target uses the same base
  // configuration for the  pinmux and pinout as defined above, and the
  // generated software constants for the pinmux DIF do not change among the
  // implementation targets. However, in order to accommodate slight
  // differences among the ASIC, FPGA emulation and simulation environments,
  // it is possible to make very limited pinout changes below. In particular,
  // it is possible to remove and tie-off specific pads, or add more 'manual'
  // pads that need to be manually connected in the template. It is also possible
  // to override the JTAG and strap locations indices, since the testing and DFT
  // setups may differ among the targets.
  targets: [
    { name: 'asic',

      // Chip level changes
      chiplevel: {
        port_overrides: {
          'rv_dm.next_dm_addr'                   : { unused:      true             },
          'soc_proxy.integrator_id'              : { unused:      true             },
          'soc_proxy.soc_lsio_trigger'           : { unused:      true             },
          'soc_proxy.soc_gpi_async'              : { unused:      true             },
          'soc_proxy.soc_gpo_async'              : { unused:      true             },
          'soc_proxy.soc_wkup_async'             : { unused:      true             },
          'soc_proxy.misc_tl_h2d'                : { feedthrough: true             },
          'soc_proxy.misc_tl_d2h'                : { feedthrough: true             },
          'ac_range_check.range_check_overwrite' : { feedthrough: true             },
          'ac_range_check.ctn_filtered_tl_h2d'   : { signal:      "ctn_tl_h2d[0]"  },
          'ac_range_check.ctn_filtered_tl_d2h'   : { signal:      "ctn_tl_d2h[0]"  },
          'racl_ctrl.racl_policies'              : { unused:      true             },
          'racl_ctrl.racl_error_external'        : { signal:      "ext_racl_error" },
          'clkmgr.cg_en'                         : { unused:      true             },
          'rstmgr.rst_en'                        : { unused:      true             },
          'pwrmgr.ext_rst_ack'                   : { unused:      true             },
          'pwrmgr.boot_status'                   : { signal:     'pwrmgr_boot_status' },
          'soc_dbg_ctrl.halt_cpu_boot'           : { unused:      true             },
          'soc_dbg_ctrl.soc_dbg_policy_bus'      : { unused:      true             },
          'ast.lc_hw_debug_en'                   : { unused:      true             },
          'ast.lc_dft_en'                        : { signal:      'lc_dft_en'      },
          'dma.sys'                              : { unused:      true             },
          'mbx.tl_mbx'                           : { unused:      true             },
          'dbg.tl_dbg'                           : { signal:      'dmi'            },
          'otp_macro.ext_voltage_h'              : { signal:      'OTP_EXT_VOLT'   },
          # Mailboxes
          'mbx0.doe_intr'                   : { unused: true },
          'mbx0.doe_intr_en'                : { unused: true },
          'mbx0.doe_intr_support'           : { unused: true },
          'mbx0.doe_async_msg_support'      : { unused: true },
          'mbx1.doe_intr'                   : { unused: true },
          'mbx1.doe_intr_en'                : { unused: true },
          'mbx1.doe_intr_support'           : { unused: true },
          'mbx1.doe_async_msg_support'      : { unused: true },
          'mbx2.doe_intr'                   : { unused: true },
          'mbx2.doe_intr_en'                : { unused: true },
          'mbx2.doe_intr_support'           : { unused: true },
          'mbx2.doe_async_msg_support'      : { unused: true },
          'mbx3.doe_intr'                   : { unused: true },
          'mbx3.doe_intr_en'                : { unused: true },
          'mbx3.doe_intr_support'           : { unused: true },
          'mbx3.doe_async_msg_support'      : { unused: true },
          'mbx4.doe_intr'                   : { unused: true },
          'mbx4.doe_intr_en'                : { unused: true },
          'mbx4.doe_intr_support'           : { unused: true },
          'mbx4.doe_async_msg_support'      : { unused: true },
          'mbx5.doe_intr'                   : { unused: true },
          'mbx5.doe_intr_en'                : { unused: true },
          'mbx5.doe_intr_support'           : { unused: true },
          'mbx5.doe_async_msg_support'      : { unused: true },
          'mbx6.doe_intr'                   : { unused: true },
          'mbx6.doe_intr_en'                : { unused: true },
          'mbx6.doe_intr_support'           : { unused: true },
          'mbx6.doe_async_msg_support'      : { unused: true },
          'mbx_jtag.doe_intr'               : { unused: true },
          'mbx_jtag.doe_intr_en'            : { unused: true },
          'mbx_jtag.doe_intr_support'       : { unused: true },
          'mbx_jtag.doe_async_msg_support'  : { unused: true },
          'mbx_pcie0.doe_intr'              : { unused: true },
          'mbx_pcie0.doe_intr_en'           : { unused: true },
          'mbx_pcie0.doe_intr_support'      : { unused: true },
          'mbx_pcie0.doe_async_msg_support' : { unused: true },
          'mbx_pcie1.doe_intr'              : { unused: true },
          'mbx_pcie1.doe_intr_en'           : { unused: true },
          'mbx_pcie1.doe_intr_support'      : { unused: true },
          'mbx_pcie1.doe_async_msg_support' : { unused: true },
        }
      },

      // Pinout Changes.
      pinout: {
        // This is a list of port names to remove from the chip port list.
        // The corresponding pad of a removed port will remain instantiated,
        // and a wire net will be declared inside the chip-level hierarchy so
        // that it can be manually connected as needed.
        remove_ports: [],

        // This is a list of pad names to remove from the base pinout defined
        // above. Removed pads will be stubbed off such that their inputs
        // signals are driven  with zero. Output signals and output enables
        // will be left unconnected. If no changes are needed, this list can
        // be left empty.
        remove_pads: [],

        // This is a list of additional "manual" pads to add to the pinout.
        // The pad entries have the same format as the pad entries in the pinout
        // configuration above. However, the 'connection' key must always be set
        // to 'manual' as it is not possible to connect these additional pads
        // to the pinmux or peripherals.
        add_pads: [],
      },

      pinmux: {
        // Special signal positions. Each entry in the list below creates a
        // target-specific pad position parameter in the chiplevel hierarchy
        // that can be used to parameterize certain IPs like the pinmux or
        // padring. This is mainly used to define the pad positions of special
        // test and DFT signals such as the JTAG signals and the TAP and DFT
        // straps. Straps in this context are special pads that get sampled at
        // boot time during certain life cycle states in order to determine
        // DFT modes and the TAP mux selection index (the JTAG signals can be
        // muxed to either the lifecycle TAP, DFT TAP or RISC-V processor
        // TAP). TODO: add more documentation to https://docs.opentitan.org/hw/ip/pinmux/doc/index.html
        // Each entry must have the following two keys:
        //
        // - name: Basename for the SV parameter.
        //
        // - pad: The pad name that this special signal maps to. The generated
        //        parameter will be assigned the corresponding pad index.
        //
        // Each entry may have an optional 'desc' key for further description.
        special_signals: [],
      }
    },
    { name: 'verilator',

      // The verilator chip-level has no physical pads: the flat per-peripheral
      // signals are connected to the testbench DPI models through the
      // padring_verilator module. The overrides mirror the asic target (the
      // verilator chip-level keeps the same TAP / CTN / soc_proxy / memory
      // configuration infrastructure), except otp_macro.ext_voltage_h, which
      // is an inout pad on the asic and therefore left open here.
      chiplevel: {
        port_overrides: {
          'rv_dm.next_dm_addr'                   : { unused:      true             },
          'soc_proxy.integrator_id'              : { unused:      true             },
          'soc_proxy.soc_lsio_trigger'           : { unused:      true             },
          'soc_proxy.soc_gpi_async'              : { unused:      true             },
          'soc_proxy.soc_gpo_async'              : { unused:      true             },
          'soc_proxy.soc_wkup_async'             : { unused:      true             },
          'soc_proxy.misc_tl_h2d'                : { feedthrough: true             },
          'soc_proxy.misc_tl_d2h'                : { feedthrough: true             },
          'ac_range_check.range_check_overwrite' : { feedthrough: true             },
          'ac_range_check.ctn_filtered_tl_h2d'   : { signal:      "ctn_tl_h2d[0]"  },
          'ac_range_check.ctn_filtered_tl_d2h'   : { signal:      "ctn_tl_d2h[0]"  },
          'racl_ctrl.racl_policies'              : { unused:      true             },
          'racl_ctrl.racl_error_external'        : { signal:      "ext_racl_error" },
          'clkmgr.cg_en'                         : { unused:      true             },
          'rstmgr.rst_en'                        : { unused:      true             },
          'pwrmgr.ext_rst_ack'                   : { unused:      true             },
          'pwrmgr.boot_status'                   : { signal:     'pwrmgr_boot_status' },
          'soc_dbg_ctrl.halt_cpu_boot'           : { unused:      true             },
          'soc_dbg_ctrl.soc_dbg_policy_bus'      : { unused:      true             },
          'ast.lc_hw_debug_en'                   : { unused:      true             },
          'ast.lc_dft_en'                        : { signal:      'lc_dft_en'      },
          'dma.sys'                              : { unused:      true             },
          'mbx.tl_mbx'                           : { unused:      true             },
          'dbg.tl_dbg'                           : { signal:      'dmi'            },
          'otp_macro.ext_voltage_h'              : { unused: true, tie_value: "" },
          # Memory configuration ports default to chiplevel nets driven by u_ast
          # (same as the asic target); no per-port overrides required.
          # Mailboxes
          'mbx0.doe_intr'                   : { unused: true },
          'mbx0.doe_intr_en'                : { unused: true },
          'mbx0.doe_intr_support'           : { unused: true },
          'mbx0.doe_async_msg_support'      : { unused: true },
          'mbx1.doe_intr'                   : { unused: true },
          'mbx1.doe_intr_en'                : { unused: true },
          'mbx1.doe_intr_support'           : { unused: true },
          'mbx1.doe_async_msg_support'      : { unused: true },
          'mbx2.doe_intr'                   : { unused: true },
          'mbx2.doe_intr_en'                : { unused: true },
          'mbx2.doe_intr_support'           : { unused: true },
          'mbx2.doe_async_msg_support'      : { unused: true },
          'mbx3.doe_intr'                   : { unused: true },
          'mbx3.doe_intr_en'                : { unused: true },
          'mbx3.doe_intr_support'           : { unused: true },
          'mbx3.doe_async_msg_support'      : { unused: true },
          'mbx4.doe_intr'                   : { unused: true },
          'mbx4.doe_intr_en'                : { unused: true },
          'mbx4.doe_intr_support'           : { unused: true },
          'mbx4.doe_async_msg_support'      : { unused: true },
          'mbx5.doe_intr'                   : { unused: true },
          'mbx5.doe_intr_en'                : { unused: true },
          'mbx5.doe_intr_support'           : { unused: true },
          'mbx5.doe_async_msg_support'      : { unused: true },
          'mbx6.doe_intr'                   : { unused: true },
          'mbx6.doe_intr_en'                : { unused: true },
          'mbx6.doe_intr_support'           : { unused: true },
          'mbx6.doe_async_msg_support'      : { unused: true },
          'mbx_jtag.doe_intr'               : { unused: true },
          'mbx_jtag.doe_intr_en'            : { unused: true },
          'mbx_jtag.doe_intr_support'       : { unused: true },
          'mbx_jtag.doe_async_msg_support'  : { unused: true },
          'mbx_pcie0.doe_intr'              : { unused: true },
          'mbx_pcie0.doe_intr_en'           : { unused: true },
          'mbx_pcie0.doe_intr_support'      : { unused: true },
          'mbx_pcie0.doe_async_msg_support' : { unused: true },
          'mbx_pcie1.doe_intr'              : { unused: true },
          'mbx_pcie1.doe_intr_en'           : { unused: true },
          'mbx_pcie1.doe_intr_support'      : { unused: true },
          'mbx_pcie1.doe_async_msg_support' : { unused: true },
        }
      },

      // The verilator target has no physical pads, so there is nothing to
      // remove or add here.
      pinout: {
        remove_ports: [],
        remove_pads: [],
        add_pads: [],
      },

      pinmux: {
        special_signals: [],
      }
    },
  ]
}
